# Ansys Electronics Desktop project, version 2023.2
materials:
  vacuum: permittivity=1
  silicon: permittivity=11.49 dielectric_loss_tangent=2.5e-06
  sapphire: permittivity=10 dielectric_loss_tangent=1.9e-06
  PMLGroup1_Z_1: permittivity{anisotropic component1=491.94367 component2=491.94367 component3=0.0010163765} permeability{anisotropic component1=491.94367 component2=491.94367 component3=0.0010163765} dielectric_loss_tangent{anisotropic component1=1 component2=1 component3=-1} magnetic_loss_tangent{anisotropic component1=1 component2=1 component3=-1}
  PMLGroup1_Z_2: permittivity{anisotropic component1=44.477604 component2=44.477604 component3=1.1241613} permeability{anisotropic component1=4.4477604 component2=4.4477604 component3=0.11241613} dielectric_loss_tangent{anisotropic component1=1 component2=1 component3=-1} magnetic_loss_tangent{anisotropic component1=1 component2=1 component3=-1}

design cavity_only_eigenmode (HFSS, Eigenmode, model units mm)
variables:
  xsub = 40mm
  ysub = 40mm
  hsub = 0.5mm
  hcav = 0.3mm
  ycav = 22mm
  xcav = 24mm
  angle_a = 54.7
  angle_b = 90 - angle_a
  leg_length = hcav / tan(angle_b * pi / 180)
  h_chip = 0.4mm
  xchip = xcav
  ychip = ysub
  hchip = 0.4mm
geometry:
  substrate [silicon] = box(corner=(0mm, 0mm, 0mm), size=(xsub, ysub, hsub))
  cut_profile [vacuum] = polyline(x=xsub/2+xcav/2, yz: (ysub/2-ycav/2, hsub) (ysub/2-ycav/2+leg_length, hsub-hcav) (ysub/2+ycav/2-leg_length, hsub-hcav) (ysub/2+ycav/2, hsub) (ysub/2-ycav/2, hsub), closed, covered)
  cut_profile.thicken(-xcav)
  cut_profile_1 = cut_profile.copy()
  substrate.subtract(cut_profile_1)
  top_chip [sapphire] = box(corner=(xsub/2-xchip/2, 0mm, hsub), size=(xchip, ychip, hchip))
  Rectangle1 = rectangle(corner=(xsub/2-xcav/2, ysub/2-ycav/2, hsub), x_size=xcav, y_size=ycav)
  top_chip_ObjectFromFace1 = object_from(top_chip.face(-z))
  top_chip_ObjectFromFace1.subtract(Rectangle1)
boundaries and excitations:
  cavity_top: Perfect E Faces=cut_profile.face(at (20, 20, 0.5))
  cavity_boundary: Perfect E Faces=cut_profile.face(at (8, 20, 0.35), at (20, 30.7881, 0.35), at (32, 20, 0.35), at (20, 9.21185, 0.35), at (20, 20, 0.2))
mesh:
  cavity_sidewall_mesh: LengthBased Faces=cut_profile.face(at (32, 20, 0.35), at (20, 30.7881, 0.35), at (8, 20, 0.35), at (20, 9.21185, 0.35)) MaxLength=0.6mm
  cavity_top_bottom_mesh: LengthBased Faces=cut_profile.face(at (20, 20, 0.5), at (20, 20, 0.2)) MaxLength=0.6mm
  substrate_top_bottom_mesh: LengthBased Faces=substrate.face(-z) MaxLength=1mm
  substrate_side_mesh: LengthBased Faces=substrate.face(+y, -x, +x, -y) MaxLength=1mm
  chip_edge_mesh: LengthBased Faces=top_chip.face(+x, +y, -x, -y) MaxLength=1mm
  chip_top_meash: LengthBased Faces=top_chip.face(+z) MaxLength=1mm
setups:
  Setup1: HfssEigen MinimumFrequency=8GHz NumModes=6 MaxDeltaFreq=0.05 ConvergeOnRealFreq=true MaximumPasses=30 MinimumPasses=1 MinimumConvergedPasses=1 PercentRefinement=30 BasisOrder=-1
source amplitudes:
  #-10:1: 1 0deg
  #-10:2..#-10:6: 0 0deg
optimetrics:
  xycav_sweep: Parametric Sim._Setups=[Setup1]
    sweep xcav: LIN 1mm 5mm 1mm
    sweep ycav: LIN 1mm 5mm 1mm
field calculator expressions:
  UEvac = Mag_E | 2 | Pow | EnterVolume(cut_profile) | VolumeValue | Integrate | 8.854187817e-12 | * | 0.5 | *
  UEsub = Mag_E | 2 | Pow | EnterVolume(substrate) | VolumeValue | Integrate | 1.0173461801733e-10 | * | 0.5 | *
  UEchip = Mag_E | 2 | Pow | EnterVolume(top_chip) | VolumeValue | Integrate | 8.854187817e-12 | * | 10 | * | 0.5 | *
  UEtot = UEvac | UEsub | UEchip | + | +
  pe_chip = UEchip | UEtot | /
  pe_sub = UEsub | UEtot | /
  pe_vac = UEvac | UEtot | /
  Ex = Vector_E | ScalarX
  Ey = Vector_E | ScalarY
  Ez = Vector_E | ScalarZ
field plots:
  Vector_E1: E Field in substrate, cut_profile on Setup1 : LastAdaptive at Phase=0deg
  Vector_H1: H Field in substrate, cut_profile, top_chip on Setup1 : LastAdaptive at Phase=90deg
  Vector_Jsurf1: Jsurf over cut_profile.face(at (20, 20, 0.5)) on Setup1 : LastAdaptive at Phase=90deg
reports:
  Eigen Modes Plot 2: re(Mode(1)) vs xcav, ycav on Setup1 : LastAdaptive
  Eigen Modes Plot 3: re(Mode(2)) vs xcav, ycav on Setup1 : LastAdaptive
  Eigen Q Plot 1: log10(Q(1)) vs xcav, ycav on Setup1 : LastAdaptive
  Eigen Modes Plot 4: re(Mode(1)), re(Mode(2)), re(Mode(3)), re(Mode(4)), re(Mode(5)), re(Mode(6)) vs xcav on Setup1 : LastAdaptive [ycav=5mm]
  Calculator Expressions Table 1: UEvac, UEsub, UEchip, UEtot, pe_chip, pe_sub, pe_vac vs Phase on Setup1 : LastAdaptive [Phase=0deg xsub=20mm ysub=20mm ycav=15mm xcav=5mm]

design cavity_only_no_silicon_eigenmode (HFSS, Eigenmode, model units mm)
variables:
  xsub = 20mm
  ysub = 20mm
  hsub = 0.5mm
  hcav = 0.3mm
  ycav = 22mm
  xcav = 24mm
  angle_a = 54.7
  angle_b = 90 - angle_a
  leg_length = hcav / tan(angle_b * pi / 180)
  h_chip = 0.4mm
  xchip = xcav
  ychip = ysub
  hchip = 0.4mm
  gseam = 100000000S_per_m
geometry:
  cut_profile [vacuum] = polyline(x=xsub/2+xcav/2, yz: (ysub/2-ycav/2, hsub) (ysub/2-ycav/2+leg_length, hsub-hcav) (ysub/2+ycav/2-leg_length, hsub-hcav) (ysub/2+ycav/2, hsub) (ysub/2-ycav/2, hsub), closed, covered)
  cut_profile.thicken(-xcav)
  cut_profile_ObjectFromEdge1..cut_profile_ObjectFromEdge4 = object_from(cut_profile.edge(at (10, -1, 0.5), at (22, 10, 0.5), at (10, 21, 0.5), at (-2, 10, 0.5)))
mesh:
  cavity_sidewall_mesh: LengthBased Faces=cut_profile.face(at (22, 10, 0.35), at (10, 20.7881, 0.35), at (-2, 10, 0.35), at (10, -0.788147, 0.35)) MaxLength=0.6mm
  cavity_top_bottom_mesh: LengthBased Faces=cut_profile.face(at (10, 10, 0.5), at (10, 10, 0.2)) MaxLength=0.6mm
setups:
  Setup1: HfssEigen MinimumFrequency=1GHz NumModes=6 MaxDeltaFreq=0.05 ConvergeOnRealFreq=true MaximumPasses=30 MinimumPasses=1 MinimumConvergedPasses=1 PercentRefinement=30 BasisOrder=-1
source amplitudes:
  #-10:1: 1 0deg
  #-10:2..#-10:6: 0 0deg
optimetrics:
  xycav_sweep: Parametric Sim._Setups=[Setup1]
    sweep xcav: LIN 1mm 5mm 1mm
    sweep ycav: LIN 1mm 5mm 1mm
field calculator expressions:
  UEvac = Mag_E | 2 | Pow | EnterVolume(cut_profile) | VolumeValue | Integrate | 8.854187817e-12 | * | 0.5 | *
  Jint = Mag_Jsurf | 2 | Pow | EnterLine(cut_profile_ObjectFromEdge1) | LineValue | Integrate | Mag_Jsurf | 2 | Pow | EnterLine(cut_profile_ObjectFromEdge2) | LineValue | Integrate | Mag_Jsurf | 2 | Pow | EnterLine(cut_profile_ObjectFromEdge3) | LineValue | Integrate | Mag_Jsurf | 2 | Pow | EnterLine(cut_profile_ObjectFromEdge4) | LineValue | Integrate | + | + | +
  Hint = Mag_H | 2 | Pow | EnterVolume(AllObjects) | VolumeValue | Integrate | 1.25663706143592e-06 | * | 6.28318530717959 | * | Output_Variable(Freq, 4) | Real | *
  yseam = Jint | Hint | /
  seam_loss = yseam | Scalar_Function(FuncValue='gseam') | /
  UEtot = Mag_E | 2 | Pow | EnterVolume(AllObjects) | VolumeValue | Integrate | 0.5 | * | 8.854187817e-12 | *
  Ey = Vector_E | ScalarY
  Ex = Vector_E | ScalarX
  Ez = Vector_E | ScalarZ
field plots:
  Vector_E1: E Field in cut_profile on Setup1 : LastAdaptive at Phase=0deg
reports:
  Calculator Expressions Table 1: yseam, seam_loss vs Phase on Setup1 : LastAdaptive [Phase=90deg ycav=all xcav=all]; UEvac, UEtot vs Phase on Setup1 : LastAdaptive [Phase=0deg ycav=all xcav=all]

design two_uncoupled_cavities_only_eigenmode (HFSS, Eigenmode, model units mm)
variables:
  xsub = 90mm
  ysub = 90mm
  hsub = 0.5mm
  hcav = 0.3mm
  ycav = 22mm
  xcav = 24mm
  angle_a = 54.7
  angle_b = 90 - angle_a
  leg_length = hcav / tan(angle_b * pi / 180)
  h_chip = 0.4mm
  xchip = 2 * xcav + cavity_offset
  ychip = ycav
  hchip = 0.4mm
  cavity_offset = 2mm
geometry:
  substrate [silicon] = box(corner=(0mm, 0mm, 0mm), size=(xsub, ysub, hsub))
  cut_profile [vacuum] = polyline(x=xsub/2+xcav/2, yz: (ysub/2-ycav/2, hsub) (ysub/2-ycav/2+leg_length, hsub-hcav) (ysub/2+ycav/2-leg_length, hsub-hcav) (ysub/2+ycav/2, hsub) (ysub/2-ycav/2, hsub), closed, covered)
  cut_profile.thicken(-xcav)
  cut_profile_1 = cut_profile.copy()
  substrate.subtract(cut_profile_1)
  top_chip [sapphire] = box(corner=(xsub/2 - xchip/2 + xcav/2 + cavity_offset/2, ysub/2-ychip/2, hsub), size=(xchip, ychip, hchip))
  cut_profile1 [vacuum] = polyline(x=xsub/2+xcav/2, yz: (ysub/2-ycav/2, hsub) (ysub/2-ycav/2+leg_length, hsub-hcav) (ysub/2+ycav/2-leg_length, hsub-hcav) (ysub/2+ycav/2, hsub) (ysub/2-ycav/2, hsub), closed, covered)
  cut_profile1.thicken(-xcav)
  cut_profile1.move(xcav + cavity_offset, 0mm, 0mm)
  cut_profile1_1 = cut_profile1.copy()
  substrate.subtract(cut_profile1_1)
boundaries and excitations:
  cavity_boundary: Perfect E Faces=cut_profile.face(at (33, 45, 0.35), at (45, 55.7881, 0.35), at (57, 45, 0.35), at (45, 34.2119, 0.35), at (45, 45, 0.2))
  cavity_boundary1: Perfect E Faces=cut_profile1.face(at (59, 45, 0.35), at (71, 55.7881, 0.35), at (83, 45, 0.35), at (71, 34.2119, 0.35), at (71, 45, 0.2))
  ground_plane: Perfect E Faces=substrate.face(+z)
mesh:
  cavity_sidewall_mesh: LengthBased Faces=cut_profile.face(at (57, 45, 0.35), at (45, 55.7881, 0.35), at (33, 45, 0.35), at (45, 34.2119, 0.35)) MaxLength=0.6mm
  cavity_top_bottom_mesh: LengthBased Faces=cut_profile.face(at (45, 45, 0.5), at (45, 45, 0.2)) MaxLength=0.6mm
  substrate_top_bottom_mesh: LengthBased Faces=substrate.face(-z) MaxLength=1mm
  substrate_side_mesh: LengthBased Faces=substrate.face(+y, -x, +x, -y) MaxLength=1mm
  chip_edge_mesh: LengthBased Faces=top_chip.face(+x, +y, -x, -y) MaxLength=1mm
  chip_top_meash: LengthBased Faces=top_chip.face(+z) MaxLength=1mm
  cavity_sidewall_mesh1: LengthBased Faces=cut_profile1.face(at (83, 45, 0.35), at (71, 55.7881, 0.35), at (59, 45, 0.35), at (71, 34.2119, 0.35)) MaxLength=0.6mm
  cavity_top_bottom_mesh1: LengthBased Faces=cut_profile1.face(at (71, 45, 0.5), at (71, 45, 0.2)) MaxLength=0.6mm
setups:
  Setup1: HfssEigen MinimumFrequency=9.45GHz NumModes=20 MaxDeltaFreq=0.05 ConvergeOnRealFreq=true MaximumPasses=30 MinimumPasses=1 MinimumConvergedPasses=1 PercentRefinement=30 BasisOrder=-1
source amplitudes:
  #-10:1..#-10:8, #-10:10..#-10:20: 0 0deg
  #-10:9: 1 0deg
field calculator expressions:
  UEvac = Mag_E | 2 | Pow | EnterVolume(cut_profile) | VolumeValue | Integrate | 8.854187817e-12 | * | 0.5 | *
  UEsub = Mag_E | 2 | Pow | EnterVolume(substrate) | VolumeValue | Integrate | 1.0173461801733e-10 | * | 0.5 | *
  UEchip = Mag_E | 2 | Pow | EnterVolume(top_chip) | VolumeValue | Integrate | 8.854187817e-12 | * | 10 | * | 0.5 | *
  UEtot = UEvac | UEsub | UEchip | + | +
  pe_chip = UEchip | UEtot | /
  pe_sub = UEsub | UEtot | /
  pe_vac = UEvac | UEtot | /
  Ex = Vector_E | ScalarX
  Ey = Vector_E | ScalarY
  Ez = Vector_E | ScalarZ
field plots:
  Vector_E1, Vector_E2: E Field in substrate, cut_profile, top_chip, cut_profile1 on Setup1 : LastAdaptive at Phase=0deg
reports:
  Calculator Expressions Table 1: pe_chip, pe_sub, pe_vac vs Phase on Setup1 : LastAdaptive [Phase=0deg]

design two_coupled_cavities_only_eigenmode (HFSS, Eigenmode, model units mm)
variables:
  xsub = 90mm
  ysub = 90mm
  hsub = 5mm
  hcav = 3mm
  ycav = 22mm
  xcav = 24mm
  angle_a = 54.7
  angle_b = 90 - angle_a
  leg_length = hcav / tan(angle_b * pi / 180)
  h_chip = 0.4mm
  xchip = 2 * xcav + cavity_offset
  ychip = ycav
  hchip = 2mm
  cavity_offset = 2mm
  xtunnel = cavity_offset + 2 mm
  ytunnel = 4mm
geometry:
  substrate [silicon] = box(corner=(0mm, 0mm, 0mm), size=(xsub, ysub, hsub))
  cut_profile [vacuum] = polyline(x=xsub/2+xcav/2, yz: (ysub/2-ycav/2, hsub) (ysub/2-ycav/2+leg_length, hsub-hcav) (ysub/2+ycav/2-leg_length, hsub-hcav) (ysub/2+ycav/2, hsub) (ysub/2-ycav/2, hsub), closed, covered)
  cut_profile.thicken(-xcav)
  top_chip [sapphire] = box(corner=(xsub/2 - xchip/2 + xcav/2 + cavity_offset/2, ysub/2-ychip/2, hsub), size=(xchip, ychip, hchip))
  cut_profile1 = polyline(x=xsub/2+xcav/2, yz: (ysub/2-ycav/2, hsub) (ysub/2-ycav/2+leg_length, hsub-hcav) (ysub/2+ycav/2-leg_length, hsub-hcav) (ysub/2+ycav/2, hsub) (ysub/2-ycav/2, hsub), closed, covered)
  cut_profile1.thicken(-xcav)
  cut_profile1.move(xcav + cavity_offset, 0mm, 0mm)
  tunnel = box(corner=(xsub/2+xcav/2-cavity_offset/2, ysub/2 - ytunnel/2, hsub-hcav), size=(xtunnel, ytunnel, hcav))
  cut_profile.unite(cut_profile1, tunnel)
  cut_profile_1 = cut_profile.copy()
  substrate.subtract(cut_profile_1)
boundaries and excitations:
  cavity_boundary: Perfect E Faces=cut_profile.face(all 14)
  ground_plane: Perfect E Faces=substrate.face(+z)
mesh:
  gnd_plane_mesh: LengthBased Faces=substrate.face(+z) MaxLength="4 * cavity_offset"
  chip_sidewall_mesh: LengthBased Faces=top_chip.face(-y, +x, +y, -x) MaxLength=hchip
  chip_top_mesh: LengthBased Faces=top_chip.face(+z) MaxLength="ychip / 2"
  substrate_sidewall_mesh: LengthBased Faces=substrate.face(+x, +y, -y, -x) MaxLength=hsub
  substrate_bottom_mesh: LengthBased Faces=substrate.face(-z) MaxLength="xsub / 10"
  cavity_constriction_mesh: LengthBased Faces=cut_profile.face(at (57, 51.527, 3.5), at (58, 47, 3.5), at (59, 51.527, 3.5), at (59, 38.473, 3.5), at (57, 38.473, 3.5), at (58, 43, 3.5), at (33, 45, 3.5), at (83, 45, 3.5)) MaxLength=cavity_offset
  cavity_sidewall_mesh: LengthBased Faces=cut_profile.face(at (71, 36.1185, 3.5), at (45, 36.1185, 3.5), at (45, 53.8815, 3.5), at (71, 53.8815, 3.5), at (58, 45, 2)) MaxLength="xcav / 10"
setups:
  Setup1: HfssEigen MinimumFrequency=9.45GHz NumModes=20 MaxDeltaFreq=0.05 ConvergeOnRealFreq=true MaximumPasses=30 MinimumPasses=3 MinimumConvergedPasses=3 PercentRefinement=30 BasisOrder=-1
source amplitudes:
  #-10:1..#-10:18, #-10:20: 0 0deg
  #-10:19: 1 0deg
field calculator expressions:
  UEvac = Mag_E | 2 | Pow | EnterVolume(cut_profile) | VolumeValue | Integrate | 8.854187817e-12 | * | 0.5 | *
  UEsub = Mag_E | 2 | Pow | EnterVolume(substrate) | VolumeValue | Integrate | 1.0173461801733e-10 | * | 0.5 | *
  UEchip = Mag_E | 2 | Pow | EnterVolume(top_chip) | VolumeValue | Integrate | 8.854187817e-12 | * | 10 | * | 0.5 | *
  UEtot = UEvac | UEsub | UEchip | + | +
  pe_chip = UEchip | UEtot | /
  pe_sub = UEsub | UEtot | /
  pe_vac = UEvac | UEtot | /
  Ex = Vector_E | ScalarX
  Ey = Vector_E | ScalarY
  Ez = Vector_E | ScalarZ
field plots:
  Vector_E2: E Field in substrate, cut_profile, top_chip on Setup1 : LastAdaptive at Phase=0deg
reports:
  Calculator Expressions Table 1: pe_chip, pe_sub, pe_vac vs Phase on Setup1 : LastAdaptive [Phase=0deg]

design two_coupled_cavities_plus_jj_no_silicon_version_a_eigenmode (HFSS, Eigenmode, model units mm)
variables:
  xsub = 90mm
  ysub = 90mm
  hsub = 5mm
  hcav = 3mm
  ycav = 22mm
  xcav = 24mm
  angle_a = 54.7
  angle_b = 90 - angle_a
  leg_length = hcav / tan(angle_b * pi / 180)
  h_chip = 0.4mm
  xchip = 2 * xcav + cavity_offset
  ychip = ycav
  hchip = 2mm
  cavity_offset = 2mm
  xtunnel = cavity_offset + 2 mm
  ytunnel = 4mm
  lpad = 0.5 * (cavity_offset - ljunc) - ltaper
  wpad = 0.2mm
  ljunc = 50um
  wjunc = 50um
  ltaper = 100um
  LJ = 0.5nH
geometry:
  cut_profile [vacuum] = polyline(x=xsub/2+xcav/2, yz: (ysub/2-ycav/2, hsub) (ysub/2-ycav/2+leg_length, hsub-hcav) (ysub/2+ycav/2-leg_length, hsub-hcav) (ysub/2+ycav/2, hsub) (ysub/2-ycav/2, hsub), closed, covered)
  cut_profile.thicken(-xcav)
  cut_profile1 = polyline(x=xsub/2+xcav/2, yz: (ysub/2-ycav/2, hsub) (ysub/2-ycav/2+leg_length, hsub-hcav) (ysub/2+ycav/2-leg_length, hsub-hcav) (ysub/2+ycav/2, hsub) (ysub/2-ycav/2, hsub), closed, covered)
  cut_profile1.thicken(-xcav)
  cut_profile1.move(xcav + cavity_offset, 0mm, 0mm)
  tunnel = box(corner=(xsub/2+xcav/2-cavity_offset/2, ysub/2 - ytunnel/2, hsub-hcav), size=(xtunnel, ytunnel, hcav))
  cut_profile.unite(cut_profile1, tunnel)
  left_pad = rectangle(corner=(xsub/2+xcav/2+cavity_offset, ysub/2-ycav/2, hsub), x_size=xcav, y_size=ycav)
  right_pad = left_pad.duplicate_along_line(step=(-26mm, 0mm, 0mm), total=2)
  left_jj_pad = rectangle(corner=(xsub/2+xcav/2+cavity_offset-lpad, ysub/2-wpad/2, hsub), x_size=lpad, y_size=wpad)
  right_jj_pad = rectangle(corner=(xsub/2+xcav/2+cavity_offset-2*(ltaper + lpad) - ljunc, ysub/2-wpad/2, hsub), x_size=lpad, y_size=wpad)
  left_jj_taper = rectangle(corner=(xsub/2+xcav/2+cavity_offset-lpad-ltaper, ysub/2-wjunc/2, hsub), x_size=ltaper, y_size=wjunc)
  right_jj_taper = rectangle(corner=(xsub/2+xcav/2+cavity_offset-lpad-2 * ltaper - ljunc, ysub/2-wjunc/2, hsub), x_size=ltaper, y_size=wjunc)
  jj = rectangle(corner=(xsub/2+xcav/2+cavity_offset-lpad-ltaper- ljunc, ysub/2-wjunc/2, hsub), x_size=ljunc, y_size=wjunc)
  chip [sapphire] = box(corner=(xsub/2 - xchip/2 + xcav/2 + cavity_offset/2, ysub/2-ychip/2, hsub), size=(xchip, ychip, hchip))
boundaries and excitations:
  cavity_boundary: Perfect E Faces=cut_profile.face(at (71, 53.8815, 3.5), at (59, 51.527, 3.5), at (58, 47, 3.5), at (57, 51.527, 3.5), at (45, 53.8815, 3.5), at (83, 45, 3.5), at (33, 45, 3.5), at (45, 36.1185, 3.5), at (57, 38.473, 3.5), at (59, 38.473, 3.5), at (58, 43, 3.5), at (71, 36.1185, 3.5)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)
  left_plate: Perfect E Objects=[left_jj_pad, left_jj_taper, left_pad]
  right_plate: Perfect E Objects=[right_jj_pad, right_jj_taper, right_pad]
  LumpRLC1: Lumped RLC Objects=jj CurrentLine{(58.025, 45, 5) -> (57.975, 45, 5)} RLC_Type=Parallel Inductance=LJ
mesh:
  cavity_constriction_mesh: LengthBased Faces=cut_profile.face(at (57, 51.527, 3.5), at (58, 47, 3.5), at (59, 51.527, 3.5), at (59, 38.473, 3.5), at (57, 38.473, 3.5), at (58, 43, 3.5), at (33, 45, 3.5), at (83, 45, 3.5)) MaxLength=cavity_offset
  cavity_sidewall_mesh: LengthBased Faces=cut_profile.face(at (71, 36.1185, 3.5), at (45, 36.1185, 3.5), at (45, 53.8815, 3.5), at (71, 53.8815, 3.5), at (58, 45, 2)) MaxLength="xcav / 10"
  chip_sidewall_mesh: LengthBased Faces=chip.face(+y, -x, +x, -y) MaxLength=hchip
  chip_top_mesh: LengthBased Faces=chip.face(+z) MaxLength=xchip/5
setups:
  Setup1: HfssEigen MinimumFrequency=9.45GHz NumModes=20 MaxDeltaFreq=0.05 ConvergeOnRealFreq=true MaximumPasses=30 MinimumPasses=3 MinimumConvergedPasses=2 PercentRefinement=30 BasisOrder=-1
source amplitudes:
  #-10:1..#-10:6, #-10:8..#-10:20: 0 0deg
  #-10:7: 1 0deg
optimetrics:
  LJ_sweep: Parametric Sim._Setups=[Setup1]
    sweep LJ: DEC 0.5nH 50nH 3
field calculator expressions:
  UEvac = Mag_E | 2 | Pow | EnterVolume(cut_profile) | VolumeValue | Integrate | 8.854187817e-12 | * | 0.5 | *
  Ex = Vector_E | ScalarX
  Ey = Vector_E | ScalarY
  Ez = Vector_E | ScalarZ
  UEchip = Mag_E | 2 | Pow | EnterVolume(chip) | VolumeValue | Integrate | 10 | * | 8.854187817e-12 | * | 0.5 | *
  UEtot = UEchip | UEvac | +
  pe_cav = UEvac | UEtot | /
  pe_chip = UEchip | UEtot | /
field plots:
  Vector_E2: E Field in cut_profile on Setup1 : LastAdaptive at Phase=0deg
  Vector_Jsurf1: Jsurf over cut_profile.face(at (58, 45, 5)) on Setup1 : LastAdaptive at Phase=90deg
reports:
  Eigen Modes Plot 1: re(Mode(1)), re(Mode(2)), re(Mode(3)), re(Mode(4)), re(Mode(5)), re(Mode(6)), re(Mode(7)), re(Mode(8)), re(Mode(9)), re(Mode(10)), re(Mode(11)), re(Mode(12)), re(Mode(13)), re(Mode(14)), re(Mode(15)), re(Mode(16)), re(Mode(17)), re(Mode(18)), re(Mode(19)), re(Mode(20)) vs LJ on Setup1 : LastAdaptive
  Solution Convergence Plot 1: MaxDeltaFreq vs Pass on Setup1 : AdaptivePass [LJ=all]
  Solution Convergence Plot 2: SolvedElements vs Pass on Setup1 : AdaptivePass [LJ=all]
  Calculator Expressions Plot 1: pe_cav, pe_chip vs LJ on Setup1 : LastAdaptive [Phase=0deg]

design two_coupled_cavities_plus_jjshort_no_silicon_version_b_eigenmode (HFSS, Eigenmode, model units mm)
variables:
  xsub = 90mm
  ysub = 90mm
  hsub = 5mm
  hcav = 0.3mm
  ycav = 22mm
  xcav = 24mm
  angle_a = 54.7
  angle_b = 90 - angle_a
  leg_length = hcav / tan(angle_b * pi / 180)
  h_chip = 0.4mm
  xchip = 2 * xcav + cavity_offset
  ychip = ycav
  hchip = 0.45mm
  cavity_offset = 2mm
  xtunnel = cavity_offset + 2 mm
  ytunnel = 5.5mm
  lpad = 0.5 * (cavity_offset - ljunc) - ltaper
  wpad = 0.2mm
  ljunc = 50um
  wjunc = 50um
  ltaper = 100um
  LJ = 5nH
  fsearch = 9GHz
geometry:
  cut_profile [vacuum] = polyline(x=xsub/2+xcav/2, yz: (ysub/2-ycav/2, hsub) (ysub/2-ycav/2+leg_length, hsub-hcav) (ysub/2+ycav/2-leg_length, hsub-hcav) (ysub/2+ycav/2, hsub) (ysub/2-ycav/2, hsub), closed, covered)
  cut_profile.thicken(-xcav)
  cut_profile1 = polyline(x=xsub/2+xcav/2, yz: (ysub/2-ycav/2, hsub) (ysub/2-ycav/2+leg_length, hsub-hcav) (ysub/2+ycav/2-leg_length, hsub-hcav) (ysub/2+ycav/2, hsub) (ysub/2-ycav/2, hsub), closed, covered)
  cut_profile1.thicken(-xcav)
  cut_profile1.move(xcav + cavity_offset, 0mm, 0mm)
  tunnel = box(corner=(xsub/2+xcav/2-cavity_offset/2, ysub/2 - ytunnel/2, hsub-hcav), size=(xtunnel, ytunnel, hcav))
  cut_profile.unite(cut_profile1, tunnel)
  left_pad = rectangle(corner=(xsub/2-xcav/2, ysub/2-ycav/2, hsub), x_size=2 * xcav + cavity_offset, y_size=ycav/2 - cavity_offset/2)
  right_pad = left_pad.duplicate_along_line(step=(0mm, ycav/2+cavity_offset/2, 0mm), total=2)
  left_jj_pad = rectangle(corner=(xsub/2+xcav/2+cavity_offset/2-wpad/2, ysub/2-cavity_offset/2, hsub), x_size=wpad, y_size=lpad)
  right_jj_pad = rectangle(corner=(xsub/2+xcav/2+cavity_offset/2-wpad/2, ysub/2 + ltaper + ljunc/2, hsub), x_size=wpad, y_size=lpad)
  left_jj_taper = rectangle(corner=(xsub/2+xcav/2+cavity_offset-lpad-ltaper-wjunc, ysub/2-ltaper-wjunc/2, hsub), x_size=wjunc, y_size=ltaper)
  right_jj_taper = rectangle(corner=(xsub/2+xcav/2+cavity_offset-lpad-ltaper-wjunc, ysub/2+wjunc/2, hsub), x_size=wjunc, y_size=ltaper)
  jj = rectangle(corner=(xsub/2+xcav/2+cavity_offset-lpad-ltaper- ljunc, ysub/2-wjunc/2, hsub), x_size=ljunc, y_size=wjunc)
  chip [sapphire] = box(corner=(xsub/2 - xchip/2 + xcav/2 + cavity_offset/2, ysub/2-ychip/2, hsub), size=(xchip, ychip, hchip))
boundaries and excitations:
  cavity_boundary: Perfect E Faces=cut_profile.face(at (71, 55.7881, 4.85), at (59, 51.8997, 4.85), at (58, 47.75, 4.85), at (57, 51.8997, 4.85), at (45, 55.7881, 4.85), at (83, 45, 4.85), at (33, 45, 4.85), at (45, 34.2119, 4.85), at (57, 38.1003, 4.85), at (59, 38.1003, 4.85), at (58, 42.25, 4.85), at (71, 34.2119, 4.85)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)
  left_plate: Perfect E Objects=[left_jj_pad, left_jj_taper, left_pad]
  right_plate: Perfect E Objects=[right_jj_pad, right_jj_taper, right_pad]
  jj_pec: Perfect E Objects=jj
mesh:
  cavity_constriction_mesh: LengthBased Faces=cut_profile.face(at (57, 51.8997, 4.85), at (58, 47.75, 4.85), at (59, 51.8997, 4.85), at (59, 38.1003, 4.85), at (57, 38.1003, 4.85), at (58, 42.25, 4.85), at (33, 45, 4.85), at (83, 45, 4.85)) MaxLength=cavity_offset
  cavity_sidewall_mesh: LengthBased Faces=cut_profile.face(at (71, 34.2119, 4.85), at (45, 34.2119, 4.85), at (45, 55.7881, 4.85), at (71, 55.7881, 4.85), at (58, 45, 4.7)) MaxLength="xcav / 10"
  chip_sidewall_mesh: LengthBased Faces=chip.face(+y, -x, +x, -y) MaxLength=hchip
  chip_top_mesh: LengthBased Faces=chip.face(+z) MaxLength=xchip/5
  plate_mesh: LengthBased Objects=[left_pad, right_pad] MaxLength=10mm
  pad_mesh: LengthBased Objects=[right_jj_pad, left_jj_pad] MaxLength=0.175mm
  taper_mesh: LengthBased Objects=[left_jj_taper, right_jj_taper] MaxLength=0.02mm
  jj_mesh: LengthBased Objects=jj MaxLength=0.01mm
setups:
  Setup1: HfssEigen MinimumFrequency=9.15GHz NumModes=8 MaxDeltaFreq=0.05 ConvergeOnRealFreq=true MaximumPasses=30 MinimumPasses=3 MinimumConvergedPasses=2 PercentRefinement=30 BasisOrder=-1
source amplitudes:
  #-10:1, #-10:3..#-10:8: 0 0deg
  #-10:2: 1 0deg
optimetrics:
  LJ_sweep: Parametric Sim._Setups=[Setup1]
    sweep LJ: LINC 1nH 10nH 10
  eigenmode_fsearch: Parametric Sim._Setups=[Setup1]
    sweep fsearch: LIN 4GHz 12GHz 1GHz
  plate_gap_sweep: Parametric Sim._Setups=[Setup1]
    sweep ytunnel: LIN 1mm 4.5mm 0.5mm
field calculator expressions:
  UEvac = Mag_E | 2 | Pow | EnterVolume(cut_profile) | VolumeValue | Integrate | 8.854187817e-12 | * | 0.5 | *
  Ex = Vector_E | ScalarX
  Ey = Vector_E | ScalarY
  Ez = Vector_E | ScalarZ
  UEchip = Mag_E | 2 | Pow | EnterVolume(chip) | VolumeValue | Integrate | 10 | * | 8.854187817e-12 | * | 0.5 | *
  UEtot = UEchip | UEvac | +
  pe_cav = UEvac | UEtot | /
  pe_chip = UEchip | UEtot | /
field plots:
  Vector_E2: E Field in cut_profile on Setup1 : LastAdaptive at Phase=0deg
  Vector_Jsurf1: Jsurf over cut_profile.face(at (58, 45, 5)) on Setup1 : LastAdaptive at Phase=90deg
  Vector_Jsurf2: Jsurf over right_jj_pad.face(at (58, 45.5625, 5)) right_jj_taper.face(at (58, 45.075, 5)) jj.face left_jj_taper.face(at (58, 44.925, 5)) left_jj_pad.face(at (58, 44.4375, 5)) on Setup1 : LastAdaptive at Phase=90
  Mag_E1: E Field on Setup1 : LastAdaptive at Phase=0deg
reports:
  Solution Convergence Plot 1: MaxDeltaFreq vs Pass on Setup1 : AdaptivePass [LJ=all]
  Solution Convergence Plot 2: SolvedElements vs Pass on Setup1 : AdaptivePass [LJ=all]
  Calculator Expressions Plot 1: pe_cav, pe_chip vs LJ on Setup1 : LastAdaptive [Phase=0deg]; markers m1 at 0.5nH, m2 at 0.5nH
  Eigen Q Plot 1: Q(1), Q(2), Q(3), Q(4), Q(5), Q(6), Q(7), Q(8) vs ytunnel on Setup1 : LastAdaptive [LJ=0.5nH fsearch=9GHz]
  Eigen Modes Plot 3: re(Mode(1)), re(Mode(2)), re(Mode(3)), re(Mode(4)), re(Mode(5)), re(Mode(6)), re(Mode(7)), re(Mode(8)) vs LJ on Setup1 : LastAdaptive [ytunnel=4.75mm fsearch=9GHz]; markers m1 at 1.0772173nH, m2 at 2.3207944nH, m3 at 5nH
  Eigen Modes Plot 4: re(Mode(1)), re(Mode(2)), re(Mode(3)), re(Mode(4)), re(Mode(5)), re(Mode(6)), re(Mode(7)), re(Mode(8)) vs ytunnel on Setup1 : LastAdaptive [LJ=5nH fsearch=9GHz]; markers m1 at 5.25mm, m2 at 5.25mm, m3 at 5.5mm, m4 at 5.5mm
  Calculator Expressions Plot 2: pe_cav, pe_chip vs ytunnel on Setup1 : LastAdaptive [Phase=0deg LJ=5nH fsearch=9GHz]; markers m1 at 4.75mm
  Eigen Modes Plot 5: re(Mode(1)), re(Mode(2)), re(Mode(3)), re(Mode(4)), re(Mode(5)), re(Mode(6)), re(Mode(7)), re(Mode(8)) vs LJ on Setup1 : LastAdaptive [ytunnel=5.5mm fsearch=9GHz]
  Eigen Modes Plot 6: re(Mode(1)), re(Mode(2)), re(Mode(3)), re(Mode(4)), re(Mode(5)), re(Mode(6)), re(Mode(7)), re(Mode(8)) vs LJ on Setup1 : LastAdaptive [ytunnel=5.5mm fsearch=9GHz]; markers m1 at 1nH, m2 at 1nH

design two_coupled_cavities_plus_jjopen_no_silicon_version_b_eigenmode (HFSS, Eigenmode, model units mm)
variables:
  xsub = 90mm
  ysub = 90mm
  hsub = 5mm
  hcav = 0.3mm
  ycav = 22mm
  xcav = 24mm
  angle_a = 54.7
  angle_b = 90 - angle_a
  leg_length = hcav / tan(angle_b * pi / 180)
  h_chip = 0.4mm
  xchip = 2 * xcav + cavity_offset
  ychip = ycav
  hchip = 0.45mm
  cavity_offset = 2mm
  xtunnel = cavity_offset + 2 mm
  ytunnel = 5.5mm
  lpad = 0.5 * (cavity_offset - ljunc) - ltaper
  wpad = 0.2mm
  ljunc = 50um
  wjunc = 50um
  ltaper = 100um
  LJ = 5nH
  fsearch = 9GHz
geometry:
  cut_profile [vacuum] = polyline(x=xsub/2+xcav/2, yz: (ysub/2-ycav/2, hsub) (ysub/2-ycav/2+leg_length, hsub-hcav) (ysub/2+ycav/2-leg_length, hsub-hcav) (ysub/2+ycav/2, hsub) (ysub/2-ycav/2, hsub), closed, covered)
  cut_profile.thicken(-xcav)
  cut_profile1 = polyline(x=xsub/2+xcav/2, yz: (ysub/2-ycav/2, hsub) (ysub/2-ycav/2+leg_length, hsub-hcav) (ysub/2+ycav/2-leg_length, hsub-hcav) (ysub/2+ycav/2, hsub) (ysub/2-ycav/2, hsub), closed, covered)
  cut_profile1.thicken(-xcav)
  cut_profile1.move(xcav + cavity_offset, 0mm, 0mm)
  tunnel = box(corner=(xsub/2+xcav/2-cavity_offset/2, ysub/2 - ytunnel/2, hsub-hcav), size=(xtunnel, ytunnel, hcav))
  cut_profile.unite(cut_profile1, tunnel)
  left_pad = rectangle(corner=(xsub/2-xcav/2, ysub/2-ycav/2, hsub), x_size=2 * xcav + cavity_offset, y_size=ycav/2 - cavity_offset/2)
  right_pad = left_pad.duplicate_along_line(step=(0mm, ycav/2+cavity_offset/2, 0mm), total=2)
  left_jj_pad = rectangle(corner=(xsub/2+xcav/2+cavity_offset/2-wpad/2, ysub/2-cavity_offset/2, hsub), x_size=wpad, y_size=lpad)
  right_jj_pad = rectangle(corner=(xsub/2+xcav/2+cavity_offset/2-wpad/2, ysub/2 + ltaper + ljunc/2, hsub), x_size=wpad, y_size=lpad)
  left_jj_taper = rectangle(corner=(xsub/2+xcav/2+cavity_offset-lpad-ltaper-wjunc, ysub/2-ltaper-wjunc/2, hsub), x_size=wjunc, y_size=ltaper)
  right_jj_taper = rectangle(corner=(xsub/2+xcav/2+cavity_offset-lpad-ltaper-wjunc, ysub/2+wjunc/2, hsub), x_size=wjunc, y_size=ltaper)
  chip [sapphire] = box(corner=(xsub/2 - xchip/2 + xcav/2 + cavity_offset/2, ysub/2-ychip/2, hsub), size=(xchip, ychip, hchip))
boundaries and excitations:
  cavity_boundary: Perfect E Faces=cut_profile.face(at (71, 55.7881, 4.85), at (59, 51.8997, 4.85), at (58, 47.75, 4.85), at (57, 51.8997, 4.85), at (45, 55.7881, 4.85), at (83, 45, 4.85), at (33, 45, 4.85), at (45, 34.2119, 4.85), at (57, 38.1003, 4.85), at (59, 38.1003, 4.85), at (58, 42.25, 4.85), at (71, 34.2119, 4.85)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)
  left_plate: Perfect E Objects=[left_jj_pad, left_jj_taper, left_pad]
  right_plate: Perfect E Objects=[right_jj_pad, right_jj_taper, right_pad]
mesh:
  cavity_constriction_mesh: LengthBased Faces=cut_profile.face(at (57, 51.8997, 4.85), at (58, 47.75, 4.85), at (59, 51.8997, 4.85), at (59, 38.1003, 4.85), at (57, 38.1003, 4.85), at (58, 42.25, 4.85), at (33, 45, 4.85), at (83, 45, 4.85)) MaxLength=cavity_offset
  cavity_sidewall_mesh: LengthBased Faces=cut_profile.face(at (71, 34.2119, 4.85), at (45, 34.2119, 4.85), at (45, 55.7881, 4.85), at (71, 55.7881, 4.85), at (58, 45, 4.7)) MaxLength="xcav / 10"
  chip_sidewall_mesh: LengthBased Faces=chip.face(+y, -x, +x, -y) MaxLength=hchip
  chip_top_mesh: LengthBased Faces=chip.face(+z) MaxLength=xchip/5
  plate_mesh: LengthBased Objects=[left_pad, right_pad] MaxLength=10mm
  pad_mesh: LengthBased Objects=[right_jj_pad, left_jj_pad] MaxLength=0.175mm
  taper_mesh: LengthBased Objects=[left_jj_taper, right_jj_taper] MaxLength=0.02mm
setups:
  Setup1: HfssEigen MinimumFrequency=9.15GHz NumModes=8 MaxDeltaFreq=0.05 ConvergeOnRealFreq=true MaximumPasses=30 MinimumPasses=3 MinimumConvergedPasses=2 PercentRefinement=30 BasisOrder=-1
source amplitudes:
  #-10:1, #-10:3..#-10:8: 0 0deg
  #-10:2: 1 0deg
optimetrics:
  LJ_sweep: Parametric Sim._Setups=[Setup1]
    sweep LJ: LINC 1nH 10nH 10
  eigenmode_fsearch: Parametric Sim._Setups=[Setup1]
    sweep fsearch: LIN 4GHz 12GHz 1GHz
  plate_gap_sweep: Parametric Sim._Setups=[Setup1]
    sweep ytunnel: LIN 1mm 4.5mm 0.5mm
field calculator expressions:
  UEvac = Mag_E | 2 | Pow | EnterVolume(cut_profile) | VolumeValue | Integrate | 8.854187817e-12 | * | 0.5 | *
  Ex = Vector_E | ScalarX
  Ey = Vector_E | ScalarY
  Ez = Vector_E | ScalarZ
  UEchip = Mag_E | 2 | Pow | EnterVolume(chip) | VolumeValue | Integrate | 10 | * | 8.854187817e-12 | * | 0.5 | *
  UEtot = UEchip | UEvac | +
  pe_cav = UEvac | UEtot | /
  pe_chip = UEchip | UEtot | /
field plots:
  Vector_E2: E Field in cut_profile on Setup1 : LastAdaptive at Phase=0deg
  Vector_Jsurf1: Jsurf over cut_profile.face(at (58, 45, 5)) on Setup1 : LastAdaptive at Phase=90deg
  Vector_Jsurf2: Jsurf over right_jj_pad.face(at (58, 45.5625, 5)) right_jj_taper.face(at (58, 45.075, 5)) left_jj_taper.face(at (58, 44.925, 5)) left_jj_pad.face(at (58, 44.4375, 5)) on Setup1 : LastAdaptive at Phase=90
  Mag_E1: E Field on Setup1 : LastAdaptive at Phase=0deg
reports:
  Solution Convergence Plot 1: MaxDeltaFreq vs Pass on Setup1 : AdaptivePass [LJ=all]
  Solution Convergence Plot 2: SolvedElements vs Pass on Setup1 : AdaptivePass [LJ=all]
  Calculator Expressions Plot 1: pe_cav, pe_chip vs LJ on Setup1 : LastAdaptive [Phase=0deg]; markers m1 at 0.5nH, m2 at 0.5nH
  Eigen Q Plot 1: Q(1), Q(2), Q(3), Q(4), Q(5), Q(6), Q(7), Q(8) vs ytunnel on Setup1 : LastAdaptive [LJ=0.5nH fsearch=9GHz]
  Eigen Modes Plot 3: re(Mode(1)), re(Mode(2)), re(Mode(3)), re(Mode(4)), re(Mode(5)), re(Mode(6)), re(Mode(7)), re(Mode(8)) vs LJ on Setup1 : LastAdaptive [ytunnel=4.75mm fsearch=9GHz]; markers m1 at 1.0772173nH, m2 at 2.3207944nH, m3 at 5nH
  Eigen Modes Plot 4: re(Mode(1)), re(Mode(2)), re(Mode(3)), re(Mode(4)), re(Mode(5)), re(Mode(6)), re(Mode(7)), re(Mode(8)) vs ytunnel on Setup1 : LastAdaptive [LJ=5nH fsearch=9GHz]; markers m1 at 5.25mm, m2 at 5.25mm, m3 at 5.5mm, m4 at 5.5mm
  Calculator Expressions Plot 2: pe_cav, pe_chip vs ytunnel on Setup1 : LastAdaptive [Phase=0deg LJ=5nH fsearch=9GHz]; markers m1 at 4.75mm
  Eigen Modes Plot 5: re(Mode(1)), re(Mode(2)), re(Mode(3)), re(Mode(4)), re(Mode(5)), re(Mode(6)), re(Mode(7)), re(Mode(8)) vs LJ on Setup1 : LastAdaptive [ytunnel=5.5mm fsearch=9GHz]; markers m1 at 5nH, m2 at 5nH
  Eigen Modes Plot 6: re(Mode(1)), re(Mode(2)), re(Mode(3)), re(Mode(4)), re(Mode(5)), re(Mode(6)), re(Mode(7)), re(Mode(8)) vs LJ on Setup1 : LastAdaptive [ytunnel=5.5mm fsearch=9GHz]

design two_coupled_cavities_plus_jj_no_silicon_version_a_merged_gnd_eigenmode (HFSS, Eigenmode, model units mm)
variables:
  xsub = 90mm
  ysub = 90mm
  hsub = 5mm
  hcav = 0.5mm
  ycav = 22mm
  xcav = 24mm
  angle_a = 54.7
  angle_b = 90 - angle_a
  leg_length = hcav / tan(angle_b * pi / 180)
  h_chip = 0.4mm
  xchip = 2 * xcav + cavity_offset
  ychip = ycav
  hchip = 0.45mm
  cavity_offset = 2mm
  xtunnel = cavity_offset + 2 mm
  ytunnel = 4mm
  lpad = 0.5 * (cavity_offset - ljunc) - ltaper
  wpad = 0.2mm
  ljunc = 50um
  wjunc = 50um
  ltaper = 100um
  LJ = 10nH
geometry:
  cut_profile [vacuum] = polyline(x=xsub/2+xcav/2, yz: (ysub/2-ycav/2, hsub) (ysub/2-ycav/2+leg_length, hsub-hcav) (ysub/2+ycav/2-leg_length, hsub-hcav) (ysub/2+ycav/2, hsub) (ysub/2-ycav/2, hsub), closed, covered)
  cut_profile.thicken(-xcav)
  cut_profile1 = polyline(x=xsub/2+xcav/2, yz: (ysub/2-ycav/2, hsub) (ysub/2-ycav/2+leg_length, hsub-hcav) (ysub/2+ycav/2-leg_length, hsub-hcav) (ysub/2+ycav/2, hsub) (ysub/2-ycav/2, hsub), closed, covered)
  cut_profile1.thicken(-xcav)
  cut_profile1.move(xcav + cavity_offset, 0mm, 0mm)
  tunnel = box(corner=(xsub/2+xcav/2-cavity_offset/2, ysub/2 - ytunnel/2, hsub-hcav), size=(xtunnel, ytunnel, hcav))
  cut_profile.unite(cut_profile1, tunnel)
  left_pad = rectangle(corner=(xsub/2+xcav/2+cavity_offset, ysub/2-ycav/2, hsub), x_size=xcav, y_size=ycav)
  right_pad = left_pad.duplicate_along_line(step=(-26mm, 0mm, 0mm), total=2)
  left_jj_pad = rectangle(corner=(xsub/2+xcav/2+cavity_offset-lpad, ysub/2-wpad/2, hsub), x_size=lpad, y_size=wpad)
  right_jj_pad = rectangle(corner=(xsub/2+xcav/2+cavity_offset-2*(ltaper + lpad) - ljunc, ysub/2-wpad/2, hsub), x_size=lpad, y_size=wpad)
  left_jj_taper = rectangle(corner=(xsub/2+xcav/2+cavity_offset-lpad-ltaper, ysub/2-wjunc/2, hsub), x_size=ltaper, y_size=wjunc)
  right_jj_taper = rectangle(corner=(xsub/2+xcav/2+cavity_offset-lpad-2 * ltaper - ljunc, ysub/2-wjunc/2, hsub), x_size=ltaper, y_size=wjunc)
  jj = rectangle(corner=(xsub/2+xcav/2+cavity_offset-lpad-ltaper- ljunc, ysub/2-wjunc/2, hsub), x_size=ljunc, y_size=wjunc)
  chip [sapphire] = box(corner=(xsub/2 - xchip/2 + xcav/2 + cavity_offset/2, ysub/2-ychip/2, hsub), size=(xchip, ychip, hchip))
  gnd_plane = rectangle(corner=(57mm, 34mm, 5mm), x_size=2mm, y_size=9mm)
  Rectangle2 = rectangle(corner=(57mm, 56mm, 5mm), x_size=2mm, y_size=-9mm)
  gnd_plane.unite(Rectangle2, left_pad, right_pad)
boundaries and excitations:
  cavity_boundary: Perfect E Faces=cut_profile.face(at (71, 55.6469, 4.75), at (59, 51.527, 4.75), at (58, 47, 4.75), at (57, 51.527, 4.75), at (45, 55.6469, 4.75), at (83, 45, 4.75), at (33, 45, 4.75), at (45, 34.3531, 4.75), at (57, 38.473, 4.75), at (59, 38.473, 4.75), at (58, 43, 4.75), at (71, 34.3531, 4.75)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)
  left_plate: Perfect E Objects=[left_jj_pad, left_jj_taper]
  right_plate: Perfect E Objects=[right_jj_pad, right_jj_taper]
  LumpRLC1: Lumped RLC Objects=jj CurrentLine{(58.025, 45, 5) -> (57.975, 45, 5)} RLC_Type=Parallel Inductance=LJ
  gnd: Perfect E Objects=gnd_plane
  chip_vacuum_boundary: Impedance Faces=chip.face(+y, +x, -x, -y, +z) Resistance=377 Reactance=0
mesh:
  cavity_constriction_mesh: LengthBased Faces=cut_profile.face(at (57, 51.527, 4.75), at (58, 47, 4.75), at (59, 51.527, 4.75), at (59, 38.473, 4.75), at (57, 38.473, 4.75), at (58, 43, 4.75), at (33, 45, 4.75), at (83, 45, 4.75)) MaxLength=cavity_offset
  cavity_sidewall_mesh: LengthBased Faces=cut_profile.face(at (71, 34.3531, 4.75), at (45, 34.3531, 4.75), at (45, 55.6469, 4.75), at (71, 55.6469, 4.75), at (58, 45, 4.5)) MaxLength="xcav / 10"
  chip_sidewall_mesh: LengthBased Faces=chip.face(+y, -x, +x, -y) MaxLength=hchip
  chip_top_mesh: LengthBased Faces=chip.face(+z) MaxLength=xchip/5
setups:
  Setup1: HfssEigen MinimumFrequency=9GHz NumModes=8 MaxDeltaFreq=0.005 ConvergeOnRealFreq=true MaximumPasses=30 MinimumPasses=3 MinimumConvergedPasses=2 PercentRefinement=30 BasisOrder=-1
source amplitudes:
  #-10:1, #-10:3..#-10:8: 0 0deg
  #-10:2: 1 0deg
optimetrics:
  LJ_sweep: Parametric Sim._Setups=[Setup1]
    sweep LJ: LIN 1nH 10nH 1nH
field calculator expressions:
  UEvac = Mag_E | 2 | Pow | EnterVolume(cut_profile) | VolumeValue | Integrate | 8.854187817e-12 | * | 0.5 | *
  Ex = Vector_E | ScalarX
  Ey = Vector_E | ScalarY
  Ez = Vector_E | ScalarZ
  UEchip = Mag_E | 2 | Pow | EnterVolume(chip) | VolumeValue | Integrate | 10 | * | 8.854187817e-12 | * | 0.5 | *
  UEtot = UEchip | UEvac | +
  pe_cav = UEvac | UEtot | /
  pe_chip = UEchip | UEtot | /
field plots:
  Vector_E2, Mag_E1: E Field on Setup1 : LastAdaptive at Phase=0deg
  Vector_Jsurf1: Jsurf over cut_profile.face(at (58, 45, 5)) on Setup1 : LastAdaptive at Phase=90deg
reports:
  Solution Convergence Plot 1: MaxDeltaFreq vs Pass on Setup1 : AdaptivePass [LJ=all]
  Calculator Expressions Plot 1: pe_cav, pe_chip vs LJ on Setup1 : LastAdaptive [Phase=0deg]; markers m1 at 10nH, m2 at 10nH, m3 at 7nH, m4 at 7nH
  Eigen Modes Plot 1: re(Mode(1)), re(Mode(2)), re(Mode(3)), re(Mode(4)), re(Mode(5)), re(Mode(6)), re(Mode(7)), re(Mode(8)) vs LJ on Setup1 : LastAdaptive
   Plot 1: re(Mode(2))-re(Mode(1)) vs LJ on Setup1 : LastAdaptive; markers m1 at 7nH, m2 at 1nH
  Eigen Q Plot 1: Q(1), Q(2), Q(3), Q(4), Q(5), Q(6), Q(7), Q(8) vs LJ on Setup1 : LastAdaptive

design two_coupled_cavities_plus_jj_no_silicon_version_a_merged_gnd_sidewall_vacuum_eigenmode (HFSS, Eigenmode, model units mm)
variables:
  xsub = 90mm
  ysub = 90mm
  hsub = 5mm
  hcav = 0.5mm
  ycav = 22mm
  xcav = 24mm
  angle_a = 54.7
  angle_b = 90 - angle_a
  leg_length = hcav / tan(angle_b * pi / 180)
  h_chip = 0.4mm
  xchip = 2 * xcav + cavity_offset
  ychip = ycav
  hchip = 0.45mm
  cavity_offset = 2mm
  xtunnel = cavity_offset + 2 mm
  ytunnel = 4mm
  lpad = 0.5 * (cavity_offset - ljunc) - ltaper
  wpad = 0.2mm
  ljunc = 50um
  wjunc = 50um
  ltaper = 100um
  LJ = 10nH
geometry:
  cut_profile [vacuum] = polyline(x=xsub/2+xcav/2, yz: (ysub/2-ycav/2, hsub) (ysub/2-ycav/2+leg_length, hsub-hcav) (ysub/2+ycav/2-leg_length, hsub-hcav) (ysub/2+ycav/2, hsub) (ysub/2-ycav/2, hsub), closed, covered)
  cut_profile.thicken(-xcav)
  cut_profile1 = polyline(x=xsub/2+xcav/2, yz: (ysub/2-ycav/2, hsub) (ysub/2-ycav/2+leg_length, hsub-hcav) (ysub/2+ycav/2-leg_length, hsub-hcav) (ysub/2+ycav/2, hsub) (ysub/2-ycav/2, hsub), closed, covered)
  cut_profile1.thicken(-xcav)
  cut_profile1.move(xcav + cavity_offset, 0mm, 0mm)
  tunnel = box(corner=(xsub/2+xcav/2-cavity_offset/2, ysub/2 - ytunnel/2, hsub-hcav), size=(xtunnel, ytunnel, hcav))
  cut_profile.unite(cut_profile1, tunnel)
  left_pad = rectangle(corner=(xsub/2+xcav/2+cavity_offset, ysub/2-ycav/2, hsub), x_size=xcav, y_size=ycav)
  right_pad = left_pad.duplicate_along_line(step=(-26mm, 0mm, 0mm), total=2)
  left_jj_pad = rectangle(corner=(xsub/2+xcav/2+cavity_offset-lpad, ysub/2-wpad/2, hsub), x_size=lpad, y_size=wpad)
  right_jj_pad = rectangle(corner=(xsub/2+xcav/2+cavity_offset-2*(ltaper + lpad) - ljunc, ysub/2-wpad/2, hsub), x_size=lpad, y_size=wpad)
  left_jj_taper = rectangle(corner=(xsub/2+xcav/2+cavity_offset-lpad-ltaper, ysub/2-wjunc/2, hsub), x_size=ltaper, y_size=wjunc)
  right_jj_taper = rectangle(corner=(xsub/2+xcav/2+cavity_offset-lpad-2 * ltaper - ljunc, ysub/2-wjunc/2, hsub), x_size=ltaper, y_size=wjunc)
  jj = rectangle(corner=(xsub/2+xcav/2+cavity_offset-lpad-ltaper- ljunc, ysub/2-wjunc/2, hsub), x_size=ljunc, y_size=wjunc)
  chip [sapphire] = box(corner=(xsub/2 - xchip/2 + xcav/2 + cavity_offset/2, ysub/2-ychip/2, hsub), size=(xchip, ychip, hchip))
  gnd_plane = rectangle(corner=(57mm, 34mm, 5mm), x_size=2mm, y_size=9mm)
  Rectangle2 = rectangle(corner=(57mm, 56mm, 5mm), x_size=2mm, y_size=-9mm)
  gnd_plane.unite(Rectangle2, left_pad, right_pad)
  vac_top [vacuum] = box(corner=(xsub/2-xchip/4 - xchip/8 + xcav/2 + cavity_offset/2, ysub/2-ychip/2, hsub+hchip), size=(3 * xchip/4, ychip, 3*hchip))
  Rectangle3 = rectangle(corner=(33mm, 34mm, 5.45mm), x_size=6.25mm, y_size=22mm)
  Rectangle4 = rectangle(corner=(76.75mm, 34mm, 5.45mm), x_size=6.25mm, y_size=22mm)
boundaries and excitations:
  cavity_boundary: Perfect E Faces=cut_profile.face(at (71, 55.6469, 4.75), at (59, 51.527, 4.75), at (58, 47, 4.75), at (57, 51.527, 4.75), at (45, 55.6469, 4.75), at (83, 45, 4.75), at (33, 45, 4.75), at (45, 34.3531, 4.75), at (57, 38.473, 4.75), at (59, 38.473, 4.75), at (58, 43, 4.75), at (71, 34.3531, 4.75)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)
  left_plate: Perfect E Objects=[left_jj_pad, left_jj_taper]
  right_plate: Perfect E Objects=[right_jj_pad, right_jj_taper]
  LumpRLC1: Lumped RLC Objects=jj CurrentLine{(58.025, 45, 5) -> (57.975, 45, 5)} RLC_Type=Parallel Inductance=LJ
  gnd: Perfect E Objects=gnd_plane
  chip_vacuum_boundary: Impedance Objects=Rectangle3 Faces=chip.face(-x, -y, +x, +y) Rectangle4.face Resistance=377 Reactance=0
mesh:
  cavity_constriction_mesh: LengthBased Faces=cut_profile.face(at (57, 51.527, 4.75), at (58, 47, 4.75), at (59, 51.527, 4.75), at (59, 38.473, 4.75), at (57, 38.473, 4.75), at (58, 43, 4.75), at (33, 45, 4.75), at (83, 45, 4.75)) MaxLength=cavity_offset
  cavity_sidewall_mesh: LengthBased Faces=cut_profile.face(at (71, 34.3531, 4.75), at (45, 34.3531, 4.75), at (45, 55.6469, 4.75), at (71, 55.6469, 4.75), at (58, 45, 4.5)) MaxLength="xcav / 10"
  chip_sidewall_mesh: LengthBased Faces=chip.face(+y, -x, +x, -y) MaxLength=hchip
  chip_top_mesh: LengthBased Faces=chip.face(+z) MaxLength=xchip/5
  chip_sidewall_mesh1: LengthBased Faces=vac_top.face(+y, -x, +x, -y) MaxLength=hchip
  chip_top_mesh1: LengthBased Faces=vac_top.face(+z) MaxLength=xchip/5
  top_vac_mesh: LengthBased RefineInside Objects=vac_top MaxLength=7.5mm
setups:
  Setup1: HfssEigen MinimumFrequency=9GHz NumModes=8 MaxDeltaFreq=0.005 ConvergeOnRealFreq=true MaximumPasses=30 MinimumPasses=3 MinimumConvergedPasses=2 PercentRefinement=30 BasisOrder=-1
source amplitudes:
  #-10:1, #-10:3..#-10:8: 0 0deg
  #-10:2: 1 0deg
optimetrics:
  LJ_sweep: Parametric Sim._Setups=[Setup1]
    sweep LJ: LIN 1nH 10nH 1nH
field calculator expressions:
  UEvac = Mag_E | 2 | Pow | EnterVolume(cut_profile) | VolumeValue | Integrate | 8.854187817e-12 | * | 0.5 | *
  Ex = Vector_E | ScalarX
  Ey = Vector_E | ScalarY
  Ez = Vector_E | ScalarZ
  UEchip = Mag_E | 2 | Pow | EnterVolume(chip) | VolumeValue | Integrate | 10 | * | 8.854187817e-12 | * | 0.5 | *
  UEtot = UEchip | UEvac | +
  pe_cav = UEvac | UEtot | /
  pe_chip = UEchip | UEtot | /
field plots:
  Vector_E2, Mag_E1: E Field on Setup1 : LastAdaptive at Phase=0deg
  Vector_Jsurf1: Jsurf over cut_profile.face(at (58, 45, 5)) on Setup1 : LastAdaptive at Phase=90deg
  Mesh1: MeshPlots on Setup1 : LastAdaptive at Phase=0deg
reports:
  Solution Convergence Plot 1: MaxDeltaFreq vs Pass on Setup1 : AdaptivePass [LJ=all]
  Calculator Expressions Plot 1: pe_cav, pe_chip vs LJ on Setup1 : LastAdaptive [Phase=0deg]; markers m1 at 10nH, m2 at 10nH, m3 at 7nH, m4 at 7nH
   Plot 1: re(Mode(2))-re(Mode(1)) vs LJ on Setup1 : LastAdaptive; markers m1 at 10nH, m2 at 1nH, m3 at 4nH
  Eigen Modes Plot 1: re(Mode(1)), re(Mode(2)), re(Mode(3)), re(Mode(4)), re(Mode(5)), re(Mode(6)), re(Mode(7)), re(Mode(8)) vs LJ on Setup1 : LastAdaptive
  Eigen Q Plot 1: Q(1), Q(2), Q(3), Q(4), Q(5), Q(6), Q(7), Q(8) vs LJ on Setup1 : LastAdaptive

design two_coupled_cavities_plus_jj_no_silicon_version_a_merged_gnd_no_top_chip_eigenmode (HFSS, Eigenmode, model units mm)
variables:
  xsub = 90mm
  ysub = 90mm
  hsub = 5mm
  hcav = 0.5mm
  ycav = 22mm
  xcav = 24mm
  angle_a = 54.7
  angle_b = 90 - angle_a
  leg_length = hcav / tan(angle_b * pi / 180)
  h_chip = 0.4mm
  xchip = 2 * xcav + cavity_offset
  ychip = ycav
  hchip = 0.45mm
  cavity_offset = 2mm
  xtunnel = cavity_offset + 2 mm
  ytunnel = 4mm
  lpad = 0.5 * (cavity_offset - ljunc) - ltaper
  wpad = 0.2mm
  ljunc = 50um
  wjunc = 50um
  ltaper = 100um
  LJ = 10nH
geometry:
  cut_profile [vacuum] = polyline(x=xsub/2+xcav/2, yz: (ysub/2-ycav/2, hsub) (ysub/2-ycav/2+leg_length, hsub-hcav) (ysub/2+ycav/2-leg_length, hsub-hcav) (ysub/2+ycav/2, hsub) (ysub/2-ycav/2, hsub), closed, covered)
  cut_profile.thicken(-xcav)
  cut_profile1 = polyline(x=xsub/2+xcav/2, yz: (ysub/2-ycav/2, hsub) (ysub/2-ycav/2+leg_length, hsub-hcav) (ysub/2+ycav/2-leg_length, hsub-hcav) (ysub/2+ycav/2, hsub) (ysub/2-ycav/2, hsub), closed, covered)
  cut_profile1.thicken(-xcav)
  cut_profile1.move(xcav + cavity_offset, 0mm, 0mm)
  tunnel = box(corner=(xsub/2+xcav/2-cavity_offset/2, ysub/2 - ytunnel/2, hsub-hcav), size=(xtunnel, ytunnel, hcav))
  cut_profile.unite(cut_profile1, tunnel)
  left_pad = rectangle(corner=(xsub/2+xcav/2+cavity_offset, ysub/2-ycav/2, hsub), x_size=xcav, y_size=ycav)
  right_pad = left_pad.duplicate_along_line(step=(-26mm, 0mm, 0mm), total=2)
  left_jj_pad = rectangle(corner=(xsub/2+xcav/2+cavity_offset-lpad, ysub/2-wpad/2, hsub), x_size=lpad, y_size=wpad)
  right_jj_pad = rectangle(corner=(xsub/2+xcav/2+cavity_offset-2*(ltaper + lpad) - ljunc, ysub/2-wpad/2, hsub), x_size=lpad, y_size=wpad)
  left_jj_taper = rectangle(corner=(xsub/2+xcav/2+cavity_offset-lpad-ltaper, ysub/2-wjunc/2, hsub), x_size=ltaper, y_size=wjunc)
  right_jj_taper = rectangle(corner=(xsub/2+xcav/2+cavity_offset-lpad-2 * ltaper - ljunc, ysub/2-wjunc/2, hsub), x_size=ltaper, y_size=wjunc)
  jj = rectangle(corner=(xsub/2+xcav/2+cavity_offset-lpad-ltaper- ljunc, ysub/2-wjunc/2, hsub), x_size=ljunc, y_size=wjunc)
  gnd_plane = rectangle(corner=(57mm, 34mm, 5mm), x_size=2mm, y_size=9mm)
  Rectangle2 = rectangle(corner=(57mm, 56mm, 5mm), x_size=2mm, y_size=-9mm)
  gnd_plane.unite(Rectangle2, left_pad, right_pad)
boundaries and excitations:
  cavity_boundary: Perfect E Faces=cut_profile.face(at (71, 55.6469, 4.75), at (59, 51.527, 4.75), at (58, 47, 4.75), at (57, 51.527, 4.75), at (45, 55.6469, 4.75), at (83, 45, 4.75), at (33, 45, 4.75), at (45, 34.3531, 4.75), at (57, 38.473, 4.75), at (59, 38.473, 4.75), at (58, 43, 4.75), at (71, 34.3531, 4.75)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)
  left_plate: Perfect E Objects=[left_jj_pad, left_jj_taper]
  right_plate: Perfect E Objects=[right_jj_pad, right_jj_taper]
  LumpRLC1: Lumped RLC Objects=jj CurrentLine{(58.025, 45, 5) -> (57.975, 45, 5)} RLC_Type=Parallel Inductance=LJ
  gnd: Perfect E Objects=gnd_plane
mesh:
  cavity_constriction_mesh: LengthBased Faces=cut_profile.face(at (57, 51.527, 4.75), at (58, 47, 4.75), at (59, 51.527, 4.75), at (59, 38.473, 4.75), at (57, 38.473, 4.75), at (58, 43, 4.75), at (33, 45, 4.75), at (83, 45, 4.75)) MaxLength=cavity_offset
  cavity_sidewall_mesh: LengthBased Faces=cut_profile.face(at (71, 34.3531, 4.75), at (45, 34.3531, 4.75), at (45, 55.6469, 4.75), at (71, 55.6469, 4.75), at (58, 45, 4.5)) MaxLength="xcav / 10"
setups:
  Setup1: HfssEigen MinimumFrequency=9GHz NumModes=8 MaxDeltaFreq=0.005 ConvergeOnRealFreq=true MaximumPasses=30 MinimumPasses=3 MinimumConvergedPasses=2 PercentRefinement=30 BasisOrder=-1
source amplitudes:
  #-10:1, #-10:3..#-10:8: 0 0deg
  #-10:2: 1 0deg
optimetrics:
  LJ_sweep: Parametric Sim._Setups=[Setup1]
    sweep LJ: LIN 1nH 10nH 1nH
field calculator expressions:
  UEvac = Mag_E | 2 | Pow | EnterVolume(cut_profile) | VolumeValue | Integrate | 8.854187817e-12 | * | 0.5 | *
  Ex = Vector_E | ScalarX
  Ey = Vector_E | ScalarY
  Ez = Vector_E | ScalarZ
field plots:
  Vector_E2, Mag_E1: E Field on Setup1 : LastAdaptive at Phase=0deg
  Vector_Jsurf1: Jsurf over cut_profile.face(at (58, 45, 5)) on Setup1 : LastAdaptive at Phase=90deg
reports:
  Solution Convergence Plot 1: MaxDeltaFreq vs Pass on Setup1 : AdaptivePass [LJ=all]
  Calculator Expressions Plot 1: pe_cav, pe_chip vs LJ on Setup1 : LastAdaptive [Phase=0deg]; markers m1 at 10nH, m2 at 10nH, m3 at 7nH, m4 at 7nH
  Eigen Modes Plot 1: re(Mode(1)), re(Mode(2)), re(Mode(3)), re(Mode(4)), re(Mode(5)), re(Mode(6)), re(Mode(7)), re(Mode(8)) vs LJ on Setup1 : LastAdaptive
   Plot 1: re(Mode(2))-re(Mode(1)) vs LJ on Setup1 : LastAdaptive; markers m1 at 7nH, m2 at 1nH

design two_coupled_cavities_plus_jj_no_silicon_version_a_merged_gnd_sidewall_vacuum_full_eigenmode (HFSS, Eigenmode, model units mm)
variables:
  xsub = 90mm
  ysub = 90mm
  hsub = 5mm
  hcav = 0.5mm
  ycav = 22mm
  xcav = 24mm
  angle_a = 54.7
  angle_b = 90 - angle_a
  leg_length = hcav / tan(angle_b * pi / 180)
  h_chip = 0.4mm
  xchip = 2 * xcav + cavity_offset
  ychip = ycav
  hchip = 0.45mm
  cavity_offset = 2mm
  xtunnel = cavity_offset + 2 mm
  ytunnel = 4mm
  lpad = 0.5 * (cavity_offset - ljunc) - ltaper
  wpad = 0.2mm
  ljunc = 50um
  wjunc = 50um
  ltaper = 100um
  LJ = 1nH
  chip_offset = 4mm
geometry:
  cut_profile [vacuum] = polyline(x=xsub/2+xcav/2, yz: (ysub/2-ycav/2, hsub) (ysub/2-ycav/2+leg_length, hsub-hcav) (ysub/2+ycav/2-leg_length, hsub-hcav) (ysub/2+ycav/2, hsub) (ysub/2-ycav/2, hsub), closed, covered)
  cut_profile.thicken(-xcav)
  cut_profile1 = polyline(x=xsub/2+xcav/2, yz: (ysub/2-ycav/2, hsub) (ysub/2-ycav/2+leg_length, hsub-hcav) (ysub/2+ycav/2-leg_length, hsub-hcav) (ysub/2+ycav/2, hsub) (ysub/2-ycav/2, hsub), closed, covered)
  cut_profile1.thicken(-xcav)
  cut_profile1.move(xcav + cavity_offset, 0mm, 0mm)
  tunnel = box(corner=(xsub/2+xcav/2-cavity_offset/2, ysub/2 - ytunnel/2, hsub-hcav), size=(xtunnel, ytunnel, hcav))
  cut_profile.unite(cut_profile1, tunnel)
  left_pad = rectangle(corner=(xsub/2+xcav/2+cavity_offset, ysub/2-ycav/2, hsub), x_size=xcav, y_size=ycav)
  right_pad = left_pad.duplicate_along_line(step=(-26mm, 0mm, 0mm), total=2)
  left_jj_pad = rectangle(corner=(xsub/2+xcav/2+cavity_offset-lpad, ysub/2-wpad/2, hsub), x_size=lpad, y_size=wpad)
  right_jj_pad = rectangle(corner=(xsub/2+xcav/2+cavity_offset-2*(ltaper + lpad) - ljunc, ysub/2-wpad/2, hsub), x_size=lpad, y_size=wpad)
  left_jj_taper = rectangle(corner=(xsub/2+xcav/2+cavity_offset-lpad-ltaper, ysub/2-wjunc/2, hsub), x_size=ltaper, y_size=wjunc)
  right_jj_taper = rectangle(corner=(xsub/2+xcav/2+cavity_offset-lpad-2 * ltaper - ljunc, ysub/2-wjunc/2, hsub), x_size=ltaper, y_size=wjunc)
  jj = rectangle(corner=(xsub/2+xcav/2+cavity_offset-lpad-ltaper- ljunc, ysub/2-wjunc/2, hsub), x_size=ljunc, y_size=wjunc)
  chip [sapphire] = box(corner=(xsub/2 - xchip/2 + xcav/2 + cavity_offset/2, ysub/2-ychip/2, hsub), size=(xchip, ychip, hchip))
  gnd_plane = rectangle(corner=(57mm, 34mm, 5mm), x_size=2mm, y_size=9mm)
  Rectangle2 = rectangle(corner=(57mm, 56mm, 5mm), x_size=2mm, y_size=-9mm)
  gnd_plane.unite(Rectangle2, left_pad, right_pad)
  chip_vacuum [vacuum] = box(corner=(xsub/2 - xchip/2 + xcav/2 + cavity_offset/2 - chip_offset/2, ysub/2-ychip/2, hsub), size=(xchip + chip_offset, ychip, 2 * hchip))
boundaries and excitations:
  cavity_boundary: Perfect E Faces=cut_profile.face(at (71, 55.6469, 4.75), at (59, 51.527, 4.75), at (58, 47, 4.75), at (57, 51.527, 4.75), at (45, 55.6469, 4.75), at (83, 45, 4.75), at (33, 45, 4.75), at (45, 34.3531, 4.75), at (57, 38.473, 4.75), at (59, 38.473, 4.75), at (58, 43, 4.75), at (71, 34.3531, 4.75)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)
  left_plate: Perfect E Objects=[left_jj_pad, left_jj_taper]
  right_plate: Perfect E Objects=[right_jj_pad, right_jj_taper]
  LumpRLC1: Lumped RLC Objects=jj CurrentLine{(58.025, 45, 5) -> (57.975, 45, 5)} RLC_Type=Parallel Inductance=LJ
  gnd: Perfect E Objects=gnd_plane
mesh:
  cavity_constriction_mesh: LengthBased Faces=cut_profile.face(at (57, 51.527, 4.75), at (58, 47, 4.75), at (59, 51.527, 4.75), at (59, 38.473, 4.75), at (57, 38.473, 4.75), at (58, 43, 4.75), at (33, 45, 4.75), at (83, 45, 4.75)) MaxLength=cavity_offset
  cavity_sidewall_mesh: LengthBased Faces=cut_profile.face(at (71, 34.3531, 4.75), at (45, 34.3531, 4.75), at (45, 55.6469, 4.75), at (71, 55.6469, 4.75), at (58, 45, 4.5)) MaxLength="xcav / 10"
  chip_sidewall_mesh: LengthBased Faces=chip.face(+y, -x, +x, -y) MaxLength=hchip
  chip_top_mesh: LengthBased Faces=chip.face(+z) MaxLength=xchip/5
  chip_sidewall_mesh1: LengthBased Faces=chip_vacuum.face(+y, -x, +x, -y) MaxLength=hchip
  chip_top_mesh1: LengthBased Faces=chip_vacuum.face(+z) MaxLength=xchip/5
setups:
  Setup1: HfssEigen MinimumFrequency=9GHz NumModes=8 MaxDeltaFreq=0.008 ConvergeOnRealFreq=true MaximumPasses=30 MinimumPasses=3 MinimumConvergedPasses=2 PercentRefinement=30 BasisOrder=2
source amplitudes:
  #-10:1, #-10:3..#-10:8: 0 0deg
  #-10:2: 1 0deg
optimetrics:
  LJ_sweep: Parametric Sim._Setups=[Setup1]
    sweep LJ: LIN 1nH 10nH 1nH
field calculator expressions:
  UEvac = Mag_E | 2 | Pow | EnterVolume(cut_profile) | VolumeValue | Integrate | 8.854187817e-12 | * | 0.5 | *
  Ex = Vector_E | ScalarX
  Ey = Vector_E | ScalarY
  Ez = Vector_E | ScalarZ
  UEchip = Mag_E | 2 | Pow | EnterVolume(chip) | VolumeValue | Integrate | 10 | * | 8.854187817e-12 | * | 0.5 | *
  UEtot = UEchip | UEvac | +
  pe_cav = UEvac | UEtot | /
  pe_chip = UEchip | UEtot | /
field plots:
  Vector_E2, Mag_E1: E Field on Setup1 : LastAdaptive at Phase=0deg
  Vector_Jsurf1: Jsurf over cut_profile.face(at (58, 45, 5)) on Setup1 : LastAdaptive at Phase=90deg
  Mesh1: MeshPlots on Setup1 : LastAdaptive at Phase=0deg
  SmoothQ1: Q Fields over cut_profile.face(at (58, 45, 5)) on Setup1 : LastAdaptive at Phase=0deg
reports:
  Solution Convergence Plot 1: MaxDeltaFreq vs Pass on Setup1 : AdaptivePass [LJ=all]; markers m1 at 6
  Calculator Expressions Plot 1: pe_cav, pe_chip vs LJ on Setup1 : LastAdaptive [Phase=0deg]; markers m1 at 10nH, m2 at 10nH, m3 at 7nH, m4 at 7nH
   Plot 1: re(Mode(2))-re(Mode(1)) vs LJ on Setup1 : LastAdaptive; markers m1 at 7nH, m2 at 1nH, m3 at 4nH
  Eigen Modes Plot 1: re(Mode(1)), re(Mode(2)), re(Mode(3)), re(Mode(4)), re(Mode(5)), re(Mode(6)), re(Mode(7)), re(Mode(8)) vs LJ on Setup1 : LastAdaptive; markers m1 at 4nH, m2 at 4nH
  Eigen Q Plot 1: Q(1), Q(2), Q(3), Q(4), Q(5), Q(6), Q(7), Q(8) vs LJ on Setup1 : LastAdaptive

design two_coupled_cavities_plus_jj_no_silicon_version_a_merged_gnd_sidewall_vacuum_full_geom_sweeps_eigenmode (HFSS, Eigenmode, model units mm)
variables:
  xsub = 90mm
  ysub = 90mm
  hsub = 5mm
  hcav = 0.5mm
  ycav = 22mm
  xcav = 24mm
  angle_a = 54.7
  angle_b = 35.3
  leg_length = 0.70617532mm
  h_chip = 0.4mm
  xchip = 24mm
  ychip = 46mm
  hchip = 0.45mm
  cavity_offset = 1mm
  xtunnel = 3mm
  ytunnel = 2mm
  lpad = 0.875mm
  wpad = 0.4mm
  ljunc = 50um
  wjunc = 50um
  ltaper = 100um
  LJ = 1nH
  chip_offset = 4mm
  xcav_a = 24mm
  ycav_a = 22mm
  xcav_b = 24mm
  ycav_b = 22mm
geometry:
  cav_a [vacuum] = box(corner=(0mm, 0mm, 0mm), size=(xcav_a, ycav_a, hcav))
  cav_b = box(corner=(0mm, ycav_a + cavity_offset, 0mm), size=(xcav_a, ycav_a, hcav))
  tunnel_coupler = box(corner=(xcav_a/2-xtunnel/2, ycav_a, 0mm), size=(xtunnel, ytunnel, hcav))
  chip [sapphire] = box(corner=(0, 0mm, hcav), size=(xchip, ychip, hchip))
  chip_vacuum [vacuum] = box(corner=(0, -chip_offset/2, hcav), size=(xchip, ychip + chip_offset, 2 * hchip))
  tunnel_coupler_ObjectFromFace1 = object_from(cav_a.face(1 of 6))
  chip_ObjectFromFace1 [sapphire] = object_from(chip.face(-z))
  chip_ObjectFromFace1.subtract(tunnel_coupler_ObjectFromFace1)
  cav_a.unite(cav_b, tunnel_coupler)
  jj = rectangle(corner=(xcav_a/2, ycav_a+ytunnel/2-ljunc/2, hcav), x_size=wjunc, y_size=ljunc)
  left_taper = rectangle(corner=(xcav_a/2, ycav_a+ytunnel/2-ljunc/2-ltaper, hcav), x_size=wjunc, y_size=ltaper)
  right_taper = rectangle(corner=(xcav_a/2, ycav_a+ytunnel/2+ljunc/2, hcav), x_size=wjunc, y_size=ltaper)
  left_pad = rectangle(corner=(xcav_a/2 - wpad/2 + wjunc/2, ycav_a, hcav), x_size=wpad, y_size=ytunnel/2 - ltaper-ljunc/2)
  right_pad = rectangle(corner=(xcav_a/2 - wpad/2 + wjunc/2, ycav_a+ytunnel/2+ljunc/2+ltaper, hcav), x_size=wpad, y_size=ytunnel/2 - ltaper-ljunc/2)
  jj_line = polyline((12.025mm, 22.975mm, 0.5mm) (12.025mm, 23.025mm, 0.5mm))
boundaries and excitations:
  gnd_plane: Perfect E Objects=chip_ObjectFromFace1
  pads: Perfect E Objects=[left_pad, left_taper, right_pad, right_taper]
  LumpRLC1: Lumped RLC Objects=jj CurrentLine{(12.025, 22.975, 0.5) -> (12.025, 23.025, 0.5)} RLC_Type=Parallel Inductance=LJ
  cavity: Perfect E Faces=cav_a.face(+x, at (24, 34, 0.25), at (13.5, 22.5, 0.25), at (10.5, 22.5, 0.25), -z, at (0, 34, 0.25), -x, at (12, 45, 0.25), -y)
setups:
  Setup1: HfssEigen MinimumFrequency=8.9GHz NumModes=4 MaxDeltaFreq=0.008 ConvergeOnRealFreq=true MaximumPasses=30 MinimumPasses=4 MinimumConvergedPasses=3 PercentRefinement=30 BasisOrder=2
source amplitudes:
  #-10:1, #-10:2: 0V_per_meter 0deg
  #-10:3: 1 0deg
  #-10:4: 0 0deg
optimetrics:
  LJ_sweep: Parametric Sim._Setups=[Setup1]
    sweep LJ: DEC 0.005nH 500nH 3
  LJ_xtunnel_sweep: Parametric Sim._Setups=[Setup1]
    sweep LJ: LIN 1nH 10nH 1nH
    sweep xtunnel: LIN 2mm 6mm 1mm
  cavity_offset_sweep: Parametric Sim._Setups=[Setup1]
    sweep cavity_offset: LIN 1mm 10mm 1mm
  LJ_sweep_fine: Parametric Sim._Setups=[Setup1]
    sweep LJ: LIN 7.5nH 12.5nH 0.5nH
field calculator expressions:
  Ex = Vector_E | ScalarX
  Ey = Vector_E | ScalarY
  Ez = Vector_E | ScalarZ
  Evec = Fundamental_Quantity(0) | CmplxMag
  Hvec = <Hx,Hy,Hz> | CmplxMag
  UHvec = Hvec | Hvec | Dot | EnterVolume(AllObjects) | VolumeValue | Integrate | 6.28318530717959e-07 | *
  UHmag = Mag_H | 2 | Pow | EnterVolume(AllObjects) | VolumeValue | Integrate | 6.28318530717959e-07 | *
  UEvec = Evec | Evec | Dot | EnterVolume(AllObjects) | VolumeValue | Integrate | 4.4270939085e-12 | *
  UEmag = Mag_E | 2 | Pow | EnterVolume(AllObjects) | VolumeValue | Integrate | 4.4270939085e-12 | *
field plots:
  Vector_E1, Vector_E2: E Field on Setup1 : LastAdaptive at Phase=0deg
  Evec1, Hvec1: NamedExpr on Setup1 : LastAdaptive at Phase=0deg
  Vector_H1: H Field on Setup1 : LastAdaptive at Phase=90deg
reports:
  Eigen Modes Plot 1: re(Mode(1)), re(Mode(2)), re(Mode(3)), re(Mode(4)) vs LJ on Setup1 : LastAdaptive [xtunnel=all chip_offset=all]; markers m1 at 500nH, m2 at 500nH, m3 at 1nH, m4 at 1nH, m5 at 1nH, m6 at 1nH
  Calculator Expressions Plot 1: UHvec, UHmag vs LJ on Setup1 : LastAdaptive [xtunnel=all Phase=90deg chip_offset=all]; UEvec, UEmag, UHvec- UEvec vs LJ on Setup1 : LastAdaptive [xtunnel=all Phase=0deg,90deg chip_offset=all]
  Solution Convergence Plot 1: MaxDeltaFreq vs xsub on Setup1 : AdaptivePass [xtunnel=all LJ=all chip_offset=all Pass=all]
  Eigen Modes Plot 2: re(Mode(1)), re(Mode(2)), re(Mode(3)), re(Mode(4)) vs cavity_offset on Setup1 : LastAdaptive [xtunnel=3mm LJ=1nH chip_offset=4mm]; markers m1 at 1mm, m2 at 1mm, m3 at 2mm, m4 at 2mm
  Plot 1: re(Mode(2)) - re(Mode(1)) vs LJ on Setup1 : LastAdaptive [cavity_offset=1mm xtunnel=3mm chip_offset=4mm]; markers m1 at 0.23207944nH, m2 at 500nH
  Eigen Q Plot 1: Q(1), Q(2), Q(3), Q(4) vs LJ on Setup1 : LastAdaptive [cavity_offset=1mm xtunnel=3mm chip_offset=4mm]; markers m1 at 500nH, m2 at 500nH, m3 at 500nH

design two_coupled_cavities_no_jj_no_silicon_version_a_merged_gnd_sidewall_vacuum_full_geom_sweeps_eigenmode1 (HFSS, Eigenmode, model units mm)
variables:
  xsub = 90mm
  ysub = 90mm
  hsub = 5mm
  hcav = 0.5mm
  ycav = 22mm
  xcav = 24mm
  angle_a = 54.7
  angle_b = 90 - angle_a
  leg_length = hcav / tan(angle_b * pi / 180)
  h_chip = 0.4mm
  xchip = max(xcav_a, xcav_b) + chip_offset
  ychip = ycav_a + ycav_b + cavity_offset
  hchip = 0.45mm
  cavity_offset = 2mm
  xtunnel = 5mm
  ytunnel = cavity_offset
  lpad = 0.5 * (cavity_offset - ljunc) - ltaper
  wpad = 0.2mm
  ljunc = 50um
  wjunc = 50um
  ltaper = 150um
  LJ = 1nH
  chip_offset = 4mm
  xcav_a = 24mm
  ycav_a = 22mm
  xcav_b = 24mm
  ycav_b = 22mm
geometry:
  cav_a [vacuum] = box(corner=(0mm, 0mm, 0mm), size=(xcav_a, ycav_a, hcav))
  cav_b = box(corner=(0mm, ycav_a + cavity_offset, 0mm), size=(xcav_a, ycav_a, hcav))
  tunnel_coupler = box(corner=(xcav_a/2-xtunnel/2, ycav_a, 0mm), size=(xtunnel, ytunnel, hcav))
  chip [sapphire] = box(corner=(-chip_offset/2, 0, hcav), size=(xchip, ychip, hchip))
  chip_vacuum [vacuum] = box(corner=(-chip_offset/2, -chip_offset/2, hcav), size=(xchip, ychip + chip_offset, 2*hchip))
  cav_a.unite(cav_b, tunnel_coupler)
  left_taper = rectangle(corner=(xcav_a/2, ycav_a+ytunnel/2-ljunc/2-ltaper, hcav), x_size=wjunc, y_size=ltaper)
  right_taper = rectangle(corner=(xcav_a/2, ycav_a+ytunnel/2+ljunc/2, hcav), x_size=wjunc, y_size=ltaper)
  left_pad = rectangle(corner=(xcav_a/2 - wpad/2 + wjunc/2, ycav_a, hcav), x_size=wpad, y_size=ytunnel/2 - ltaper-ljunc/2)
  right_pad = rectangle(corner=(xcav_a/2 - wpad/2 + wjunc/2, ycav_a+ytunnel/2+ljunc/2+ltaper, hcav), x_size=wpad, y_size=ytunnel/2 - ltaper-ljunc/2)
  gnd_plane = rectangle(corner=(0mm, 0, hcav), x_size=max(xcav_a, xcav_b), y_size=ycav_a + ycav_b + cavity_offset)
  Rectangle2 = rectangle(corner=(xcav_a/2-xtunnel/2, ycav_a, hcav), x_size=xtunnel, y_size=cavity_offset)
  gnd_plane.subtract(Rectangle2)
  jj = rectangle(corner=(xcav_a/2, ycav_a+ytunnel/2-ljunc/2, hcav), x_size=wjunc, y_size=ljunc)
boundaries and excitations:
  pads: Perfect E Objects=[left_pad, left_taper, right_pad, right_taper]
  cavity_boundary: Perfect E Faces=cav_a.face(+x, at (24, 35, 0.25), -z, -y, at (19.25, 22, 0.25), at (14.5, 23, 0.25), at (19.25, 24, 0.25), at (12, 46, 0.25), at (0, 35, 0.25), -x, at (4.75, 24, 0.25), at (9.5, 23, 0.25)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)
  gnd: Perfect E Objects=gnd_plane
  LumpRLC1: Lumped RLC Objects=jj CurrentLine{(12.025, 23.025, 0.5) -> (12.025, 22.975, 0.5)} RLC_Type=Parallel Inductance=LJ
mesh:
  pad_mesh: LengthBased Faces=left_pad.face right_pad.face MaxLength=wpad
  taper_mesh: LengthBased Faces=right_taper.face left_taper.face MaxLength=wjunc
  jj_mesh: LengthBased Objects=jj MaxLength=wjunc
setups:
  Setup1: HfssEigen MinimumFrequency=8.5GHz NumModes=8 MaxDeltaFreq=0.01 ConvergeOnRealFreq=true MaximumPasses=30 MinimumPasses=3 MinimumConvergedPasses=2 PercentRefinement=30 BasisOrder=-1
source amplitudes:
  #-10:1, #-10:2, #-10:4..#-10:8: 0 0deg
  #-10:3: 1 0deg
optimetrics:
  LJ_sweep: Parametric Sim._Setups=[Setup1]
    sweep LJ: LIN 1nH 10nH 1nH
  LJ_xtunnel_sweep: Parametric Sim._Setups=[Setup1]
    sweep LJ: LIN 1nH 10nH 1nH
    sweep xtunnel: LIN 2mm 6mm 1mm
  xtunnel_sweep: Parametric Sim._Setups=[Setup1]
    sweep xtunnel: LIN 2mm 6mm 1mm
field calculator expressions:
  Ex = Vector_E | ScalarX
  Ey = Vector_E | ScalarY
  Ez = Vector_E | ScalarZ
field plots:
  Vector_E1: E Field on Setup1 : LastAdaptive at Phase=0deg
  Vector_H1: H Field on Setup1 : LastAdaptive at Phase=90
  Mesh1: MeshPlots on Setup1 : LastAdaptive at Phase=0deg
reports:
  Solution Convergence Plot 1: MaxDeltaFreq vs Pass on Setup1 : AdaptivePass [cavity_offset=all xtunnel=all LJ=all]; markers m1 at 18
  Eigen Modes Plot 1: re(Mode(1)), re(Mode(2)), re(Mode(3)), re(Mode(4)), re(Mode(5)), re(Mode(6)), re(Mode(7)), re(Mode(8)) vs LJ on Setup1 : LastAdaptive [cavity_offset=all xtunnel=all]; markers m1 at 5.6934307nH, m2 at 5nH
  Eigen Q Plot 1: Q(1), Q(2), Q(3), Q(4), Q(5), Q(6), Q(7), Q(8) vs LJ on Setup1 : LastAdaptive [cavity_offset=all xtunnel=all]
   Plot 1: re(Mode(3)) - re(Mode(2)) vs LJ on Setup1 : LastAdaptive [cavity_offset=all xtunnel=all]; markers m1 at 1nH, m2 at 8nH, m3 at 5nH
  Eigen Modes Plot 2: re(Mode(2)), re(Mode(3)) vs LJ on Setup1 : LastAdaptive [cavity_offset=all xtunnel=all]
  Eigen Modes Plot 3: re(Mode(1)), re(Mode(2)), re(Mode(3)), re(Mode(4)), re(Mode(5)), re(Mode(6)), re(Mode(7)), re(Mode(8)) vs xtunnel on Setup1 : LastAdaptive [LJ=all]
  Eigen Q Plot 2: Q(1), Q(2), Q(3), Q(4), Q(5), Q(6), Q(7), Q(8) vs xtunnel on Setup1 : LastAdaptive [LJ=all]
   Plot 2: re(Mode(3))-re(Mode(2)) vs xtunnel on Setup1 : LastAdaptive [LJ=all]; markers m1 at 4mm

design two_coupled_cavities_plus_jj_no_silicon_version_a_merged_gnd_sidewall_vacuum_full_geom_sweeps_bbq (HFSS, HFSS Modal Network, model units mm)
variables:
  xsub = 90mm
  ysub = 90mm
  hsub = 5mm
  hcav = 0.5mm
  ycav = 22mm
  xcav = 24mm
  angle_a = 54.7
  angle_b = 35.3
  leg_length = 0.70617532mm
  h_chip = 0.4mm
  xchip = 24mm
  ychip = 46mm
  hchip = 0.45mm
  cavity_offset = 2mm
  xtunnel = 4mm
  ytunnel = 2mm
  lpad = 0.825mm
  wpad = 0.2mm
  ljunc = 50um
  wjunc = 50um
  ltaper = 150um
  LJ = 1nH
  chip_offset = 4mm
  xcav_a = 24mm
  ycav_a = 22mm
  xcav_b = 24mm
  ycav_b = 22mm
geometry:
  cav_a [vacuum] = box(corner=(0mm, 0mm, 0mm), size=(xcav_a, ycav_a, hcav))
  cav_b = box(corner=(0mm, ycav_a + cavity_offset, 0mm), size=(xcav_a, ycav_a, hcav))
  tunnel_coupler = box(corner=(xcav_a/2-xtunnel/2, ycav_a, 0mm), size=(xtunnel, ytunnel, hcav))
  chip [sapphire] = box(corner=(0, 0mm, hcav), size=(xchip, ychip, hchip))
  chip_vacuum [vacuum] = box(corner=(0, -chip_offset/2, hcav), size=(xchip, ychip + chip_offset, 2 * hchip))
  tunnel_coupler_ObjectFromFace1 = object_from(cav_a.face(1 of 6))
  chip_ObjectFromFace1 [sapphire] = object_from(chip.face(-z))
  chip_ObjectFromFace1.subtract(tunnel_coupler_ObjectFromFace1)
  cav_a.unite(cav_b, tunnel_coupler)
  jj = rectangle(corner=(xcav_a/2, ycav_a+ytunnel/2-ljunc/2, hcav), x_size=wjunc, y_size=ljunc)
  left_taper = rectangle(corner=(xcav_a/2, ycav_a+ytunnel/2-ljunc/2-ltaper, hcav), x_size=wjunc, y_size=ltaper)
  right_taper = rectangle(corner=(xcav_a/2, ycav_a+ytunnel/2+ljunc/2, hcav), x_size=wjunc, y_size=ltaper)
  left_pad = rectangle(corner=(xcav_a/2 - wpad/2 + wjunc/2, ycav_a, hcav), x_size=wpad, y_size=ytunnel/2 - ltaper-ljunc/2)
  right_pad = rectangle(corner=(xcav_a/2 - wpad/2 + wjunc/2, ycav_a+ytunnel/2+ljunc/2+ltaper, hcav), x_size=wpad, y_size=ytunnel/2 - ltaper-ljunc/2)
boundaries and excitations:
  gnd_plane: Perfect E Objects=chip_ObjectFromFace1
  pads: Perfect E Objects=[left_pad, left_taper, right_pad, right_taper]
  LumpRLC1: Lumped RLC Objects=jj CurrentLine{(12.025, 22.975, 0.5) -> (12.025, 23.025, 0.5)} RLC_Type=Parallel Inductance=LJ
  1: Lumped Port Objects=jj LumpedPortType=Modal Modes{Mode1{IntLine{(12.025, 22.975, 0.5) -> (12.025, 23.025, 0.5)} CharImp=Zpi RenormImp=50ohm}} Impedance=50ohm
setups:
  Setup1: HfssDriven MultipleAdaptiveFreqsSetup{Low=9.1GHz High=9.46GHz} MaxDeltaS=0.02 MaximumPasses=6 MinimumPasses=1 MinimumConvergedPasses=1 PercentRefinement=30 BasisOrder=-1 PortAccuracy=2 DrivenSolverType="Direct Solver" SaveAnyFields=false
    sweep Sweep: 9.1GHz to 9.46GHz, 361 points; Type=Discrete
    sweep Sweep1: 9.4GHz to 9.5GHz, 401 points; Type=Discrete
source amplitudes:
  1:1: 1W 0deg
optimetrics:
  LJ_sweep: Parametric
    sweep LJ: LIN 2nH 20nH 2nH
  LJ_xtunnel_sweep: Parametric
    sweep LJ: LIN 1nH 10nH 1nH
    sweep xtunnel: LIN 2mm 6mm 1mm
  cavity_offset_sweep: Parametric
    sweep chip_offset: LIN 1mm 10mm 1mm
field calculator expressions:
  Ex = Vector_E | ScalarX
  Ey = Vector_E | ScalarY
  Ez = Vector_E | ScalarZ
reports:
  Y Parameter Plot 1: im(Y(1,1)), re(Y(1,1)) vs Freq on Setup1 : Sweep [xtunnel=all LJ=all chip_offset=all]; markers m1 at 9.17GHz

design two_coupled_cavities_plus_jj_no_silicon_version_a_merged_gnd_sidewall_vacuum_full_bbq (HFSS, HFSS Modal Network, model units mm)
variables:
  xsub = 90mm
  ysub = 90mm
  hsub = 5mm
  hcav = 0.5mm
  ycav = 22mm
  xcav = 24mm
  angle_a = 54.7
  angle_b = 90 - angle_a
  leg_length = hcav / tan(angle_b * pi / 180)
  h_chip = 0.4mm
  xchip = 2 * xcav + cavity_offset
  ychip = ycav
  hchip = 0.45mm
  cavity_offset = 2mm
  xtunnel = cavity_offset + 2 mm
  ytunnel = 4mm
  lpad = 0.5 * (cavity_offset - ljunc) - ltaper
  wpad = 0.2mm
  ljunc = 50um
  wjunc = 50um
  ltaper = 100um
  LJ = 1nH
  chip_offset = 4mm
geometry:
  cut_profile [vacuum] = polyline(x=xsub/2+xcav/2, yz: (ysub/2-ycav/2, hsub) (ysub/2-ycav/2+leg_length, hsub-hcav) (ysub/2+ycav/2-leg_length, hsub-hcav) (ysub/2+ycav/2, hsub) (ysub/2-ycav/2, hsub), closed, covered)
  cut_profile.thicken(-xcav)
  cut_profile1 = polyline(x=xsub/2+xcav/2, yz: (ysub/2-ycav/2, hsub) (ysub/2-ycav/2+leg_length, hsub-hcav) (ysub/2+ycav/2-leg_length, hsub-hcav) (ysub/2+ycav/2, hsub) (ysub/2-ycav/2, hsub), closed, covered)
  cut_profile1.thicken(-xcav)
  cut_profile1.move(xcav + cavity_offset, 0mm, 0mm)
  tunnel = box(corner=(xsub/2+xcav/2-cavity_offset/2, ysub/2 - ytunnel/2, hsub-hcav), size=(xtunnel, ytunnel, hcav))
  cut_profile.unite(cut_profile1, tunnel)
  left_pad = rectangle(corner=(xsub/2+xcav/2+cavity_offset, ysub/2-ycav/2, hsub), x_size=xcav, y_size=ycav)
  right_pad = left_pad.duplicate_along_line(step=(-26mm, 0mm, 0mm), total=2)
  left_jj_pad = rectangle(corner=(xsub/2+xcav/2+cavity_offset-lpad, ysub/2-wpad/2, hsub), x_size=lpad, y_size=wpad)
  right_jj_pad = rectangle(corner=(xsub/2+xcav/2+cavity_offset-2*(ltaper + lpad) - ljunc, ysub/2-wpad/2, hsub), x_size=lpad, y_size=wpad)
  left_jj_taper = rectangle(corner=(xsub/2+xcav/2+cavity_offset-lpad-ltaper, ysub/2-wjunc/2, hsub), x_size=ltaper, y_size=wjunc)
  right_jj_taper = rectangle(corner=(xsub/2+xcav/2+cavity_offset-lpad-2 * ltaper - ljunc, ysub/2-wjunc/2, hsub), x_size=ltaper, y_size=wjunc)
  jj = rectangle(corner=(xsub/2+xcav/2+cavity_offset-lpad-ltaper- ljunc, ysub/2-wjunc/2, hsub), x_size=ljunc, y_size=wjunc)
  chip [sapphire] = box(corner=(xsub/2 - xchip/2 + xcav/2 + cavity_offset/2, ysub/2-ychip/2, hsub), size=(xchip, ychip, hchip))
  gnd_plane = rectangle(corner=(57mm, 34mm, 5mm), x_size=2mm, y_size=9mm)
  Rectangle2 = rectangle(corner=(57mm, 56mm, 5mm), x_size=2mm, y_size=-9mm)
  gnd_plane.unite(Rectangle2, left_pad, right_pad)
  chip_vacuum [vacuum] = box(corner=(xsub/2 - xchip/2 + xcav/2 + cavity_offset/2 - chip_offset/2, ysub/2-ychip/2, hsub), size=(xchip + chip_offset, ychip, 2 * hchip))
boundaries and excitations:
  cavity_boundary: Perfect E Faces=cut_profile.face(at (71, 55.6469, 4.75), at (59, 51.527, 4.75), at (58, 47, 4.75), at (57, 51.527, 4.75), at (45, 55.6469, 4.75), at (83, 45, 4.75), at (33, 45, 4.75), at (45, 34.3531, 4.75), at (57, 38.473, 4.75), at (59, 38.473, 4.75), at (58, 43, 4.75), at (71, 34.3531, 4.75)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)
  left_plate: Perfect E Objects=[left_jj_pad, left_jj_taper]
  right_plate: Perfect E Objects=[right_jj_pad, right_jj_taper]
  LumpRLC1: Lumped RLC Objects=jj CurrentLine{(58.025, 45, 5) -> (57.975, 45, 5)} RLC_Type=Parallel Inductance=LJ
  gnd: Perfect E Objects=gnd_plane
  1: Lumped Port Objects=jj LumpedPortType=Modal Modes{Mode1{IntLine{(57.975, 45, 5) -> (58.025, 45, 5)} CharImp=Zpi RenormImp=50ohm}} Impedance=50ohm
mesh:
  cavity_constriction_mesh: LengthBased Faces=cut_profile.face(at (57, 51.527, 4.75), at (58, 47, 4.75), at (59, 51.527, 4.75), at (59, 38.473, 4.75), at (57, 38.473, 4.75), at (58, 43, 4.75), at (33, 45, 4.75), at (83, 45, 4.75)) MaxLength=cavity_offset
  cavity_sidewall_mesh: LengthBased Faces=cut_profile.face(at (71, 34.3531, 4.75), at (45, 34.3531, 4.75), at (45, 55.6469, 4.75), at (71, 55.6469, 4.75), at (58, 45, 4.5)) MaxLength="xcav / 10"
  chip_sidewall_mesh: LengthBased Faces=chip.face(+y, -x, +x, -y) MaxLength=hchip
  chip_top_mesh: LengthBased Faces=chip.face(+z) MaxLength=xchip/5
  chip_sidewall_mesh1: LengthBased Faces=chip_vacuum.face(+y, -x, +x, -y) MaxLength=hchip
  chip_top_mesh1: LengthBased Faces=chip_vacuum.face(+z) MaxLength=xchip/5
setups:
  Setup1: HfssDriven MultipleAdaptiveFreqsSetup{Low=9.325GHz High=9.365GHz} MaxDeltaS=0.02 MaximumPasses=6 MinimumPasses=3 MinimumConvergedPasses=2 PercentRefinement=30 MeshLink{ImportMesh LinkID=2784 Project="This Project*" Product=HFSS Design=two_coupled_cavities_plus_jj_no_silicon_version_a_merged_gnd_sidewall_vacuum_full_eigenmode Params{LJ=LJ angle_a=angle_a cavity_offset=cavity_offset chip_offset=chip_offset h_chip=h_chip hcav=hcav hchip=hchip hsub=hsub ljunc=ljunc ltaper=ltaper wjunc=wjunc wpad=wpad xcav=xcav xsub=xsub ycav=ycav ysub=ysub ytunnel=ytunnel} PathRelativeTo=TargetProject ApplyMeshOp} BasisOrder=2 DoLambdaRefine=false PortAccuracy=2 DrivenSolverType="Direct Solver"
    sweep Sweep: 9.325GHz to 9.365GHz, 401 points; Type=Discrete
source amplitudes:
  1:1: 1W 0deg
optimetrics:
  LJ_sweep: Parametric Sim._Setups=[Setup1]
    sweep LJ: LIN 1nH 10nH 1nH
field calculator expressions:
  UEvac = Mag_E | 2 | Pow | EnterVolume(cut_profile) | VolumeValue | Integrate | 8.854187817e-12 | * | 0.5 | *
  Ex = Vector_E | ScalarX
  Ey = Vector_E | ScalarY
  Ez = Vector_E | ScalarZ
  UEchip = Mag_E | 2 | Pow | EnterVolume(chip) | VolumeValue | Integrate | 10 | * | 8.854187817e-12 | * | 0.5 | *
  UEtot = UEchip | UEvac | +
  pe_cav = UEvac | UEtot | /
  pe_chip = UEchip | UEtot | /

design two_coupled_cavities_plus_jj_no_silicon_version_a_merged_gnd_sidewall_vacuum_full_geom_sweeps_high_aspect_eigenmode (HFSS, Eigenmode, model units mm)
variables:
  xsub = 90mm
  ysub = 90mm
  hsub = 5mm
  hcav = 0.5mm
  ycav = 48mm
  xcav = 18mm
  angle_a = 54.7
  angle_b = 35.3
  leg_length = 0.70617532mm
  h_chip = 0.4mm
  xchip = 18mm
  ychip = 98mm
  hchip = 0.45mm
  cavity_offset = 2mm
  xtunnel = 4mm
  ytunnel = 2mm
  lpad = 0.875mm
  wpad = 0.4mm
  ljunc = 50um
  wjunc = 50um
  ltaper = 100um
  LJ = 1nH
  chip_offset = 4mm
  xcav_a = 18mm
  ycav_a = 48mm
  xcav_b = 18mm
  ycav_b = 48mm
geometry:
  cav_a [vacuum] = box(corner=(0mm, 0mm, 0mm), size=(xcav_a, ycav_a, hcav))
  cav_b = box(corner=(0mm, ycav_a + cavity_offset, 0mm), size=(xcav_a, ycav_a, hcav))
  tunnel_coupler = box(corner=(xcav_a/2-xtunnel/2, ycav_a, 0mm), size=(xtunnel, ytunnel, hcav))
  chip [sapphire] = box(corner=(0, 0mm, hcav), size=(xchip, ychip, hchip))
  chip_vacuum [vacuum] = box(corner=(0, -chip_offset/2, hcav), size=(xchip, ychip + chip_offset, 2 * hchip))
  tunnel_coupler_ObjectFromFace1 = object_from(cav_a.face(1 of 6))
  chip_ObjectFromFace1 [sapphire] = object_from(chip.face(-z))
  chip_ObjectFromFace1.subtract(tunnel_coupler_ObjectFromFace1)
  cav_a.unite(cav_b, tunnel_coupler)
  jj = rectangle(corner=(xcav_a/2, ycav_a+ytunnel/2-ljunc/2, hcav), x_size=wjunc, y_size=ljunc)
  left_taper = rectangle(corner=(xcav_a/2, ycav_a+ytunnel/2-ljunc/2-ltaper, hcav), x_size=wjunc, y_size=ltaper)
  right_taper = rectangle(corner=(xcav_a/2, ycav_a+ytunnel/2+ljunc/2, hcav), x_size=wjunc, y_size=ltaper)
  left_pad = rectangle(corner=(xcav_a/2 - wpad/2 + wjunc/2, ycav_a, hcav), x_size=wpad, y_size=ytunnel/2 - ltaper-ljunc/2)
  right_pad = rectangle(corner=(xcav_a/2 - wpad/2 + wjunc/2, ycav_a+ytunnel/2+ljunc/2+ltaper, hcav), x_size=wpad, y_size=ytunnel/2 - ltaper-ljunc/2)
boundaries and excitations:
  gnd_plane: Perfect E Objects=chip_ObjectFromFace1
  pads: Perfect E Objects=[left_pad, left_taper, right_pad, right_taper]
  LumpRLC1: Lumped RLC Objects=jj CurrentLine{(9.025, 48.975, 0.5) -> (9.025, 49.025, 0.5)} RLC_Type=Parallel Inductance=LJ
  cavity: Perfect E Faces=cav_a.face(+x, at (18, 74, 0.25), at (14.5, 50, 0.25), at (14.5, 48, 0.25), at (11, 49, 0.25), at (3.5, 48, 0.25), at (7, 49, 0.25), -z, at (3.5, 50, 0.25), at (0, 74, 0.25), -x, at (9, 98, 0.25)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)
setups:
  Setup1: HfssEigen MinimumFrequency=8.5GHz NumModes=4 MaxDeltaFreq=0.008 ConvergeOnRealFreq=true MaximumPasses=30 MinimumPasses=4 MinimumConvergedPasses=3 PercentRefinement=30 BasisOrder=2
source amplitudes:
  #-10:1: 0 0deg
  #-10:2: 1 0deg
  #-10:3, #-10:4: 0V_per_meter 0deg
optimetrics:
  LJ_sweep: Parametric Sim._Setups=[Setup1]
    sweep LJ: DEC 0.0001nH 10nH 3
  LJ_sweep_zoom: Parametric Sim._Setups=[Setup1]
    sweep LJ: LIN 0.2nH 1nH 0.2nH
field calculator expressions:
  Ex = Vector_E | ScalarX
  Ey = Vector_E | ScalarY
  Ez = Vector_E | ScalarZ
field plots:
  Vector_E1: E Field on Setup1 : LastAdaptive at Phase=0deg
  Vector_Jsurf1: Jsurf over cav_a.face(+z) on Setup1 : LastAdaptive at Phase=90deg
  Vector_H1: H Field on Setup1 : LastAdaptive at Phase=90deg
  Vector_E2: E Field in cav_a on Setup1 : LastAdaptive at Phase=0deg
reports:
  Solution Convergence Plot 1: MaxDeltaFreq vs Pass on Setup1 : AdaptivePass [LJ=all]; markers m1 at 10
  Calculator Expressions Plot 1: pe_cav, pe_chip vs LJ on Setup1 : LastAdaptive [Phase=0deg]; markers m1 at 10nH, m2 at 10nH, m3 at 7nH, m4 at 7nH
  Plot 1: re(Mode(2))-re(Mode(1)) vs LJ on Setup1 : LastAdaptive [xtunnel=all lpad=all ltaper=all chip_offset=all]; markers m1 at 20nH, m2 at 50nH, m3 at 50nH, m4 at 20nH
  Plot 1: re(Mode(2))-re(Mode(1)) vs LJ on Setup1 : LastAdaptive [xtunnel=all lpad=all wpad=all ltaper=100um chip_offset=all]; markers m3 at 2.1544347nH, m4 at 0.46415888nH, m5 at 0.0001nH
  Eigen Modes Plot 1: re(Mode(1)), re(Mode(2)), re(Mode(3)), re(Mode(4)) vs LJ on Setup1 : LastAdaptive [xtunnel=6mm lpad=0.875mm wpad=0.4mm ltaper=100um chip_offset=4mm]; markers m1 at 0.21544347nH
  Eigen Modes Plot 2: re(Mode(1)), re(Mode(2)), re(Mode(3)), re(Mode(4)) vs LJ on Setup1 : LastAdaptive [xtunnel=8mm]
  Eigen Modes Plot 3: re(Mode(1)), re(Mode(2)), re(Mode(3)), re(Mode(4)) vs LJ on Setup1 : LastAdaptive [xtunnel=4mm]

design two_coupled_cavities_plus_jj_no_silicon_version_a_merged_gnd_sidewall_vacuum_full_geom_sweeps_high_aspect2_eigenmode (HFSS, Eigenmode, model units mm)
variables:
  xsub = 90mm
  ysub = 90mm
  hsub = 5mm
  hcav = 0.5mm
  ycav = 48mm
  xcav = 18mm
  angle_a = 54.7
  angle_b = 35.3
  leg_length = 0.70617532mm
  h_chip = 0.4mm
  xchip = 48mm
  ychip = 40mm
  hchip = 0.45mm
  cavity_offset = 2mm
  xtunnel = 4mm
  ytunnel = 2mm
  lpad = 0.875mm
  wpad = 0.4mm
  ljunc = 50um
  wjunc = 50um
  ltaper = 100um
  LJ = 1nH
  chip_offset = 4mm
  xcav_a = 48mm
  ycav_a = 18mm
  xcav_b = 48mm
  ycav_b = 18mm
geometry:
  cav_a [vacuum] = box(corner=(0mm, 0mm, 0mm), size=(xcav_a, ycav_a, hcav))
  cav_b = box(corner=(0mm, ycav_a + cavity_offset, 0mm), size=(xcav_a, ycav_a, hcav))
  tunnel_coupler = box(corner=(xcav_a/2-xtunnel/2, ycav_a, 0mm), size=(xtunnel, ytunnel, hcav))
  chip [sapphire] = box(corner=(0, 0mm, hcav), size=(xchip, ychip, hchip))
  chip_vacuum [vacuum] = box(corner=(0, -chip_offset/2, hcav), size=(xchip, ychip + chip_offset, 2 * hchip))
  tunnel_coupler_ObjectFromFace1 = object_from(cav_a.face(1 of 6))
  chip_ObjectFromFace1 [sapphire] = object_from(chip.face(-z))
  chip_ObjectFromFace1.subtract(tunnel_coupler_ObjectFromFace1)
  cav_a.unite(cav_b, tunnel_coupler)
  jj = rectangle(corner=(xcav_a/2, ycav_a+ytunnel/2-ljunc/2, hcav), x_size=wjunc, y_size=ljunc)
  left_taper = rectangle(corner=(xcav_a/2, ycav_a+ytunnel/2-ljunc/2-ltaper, hcav), x_size=wjunc, y_size=ltaper)
  right_taper = rectangle(corner=(xcav_a/2, ycav_a+ytunnel/2+ljunc/2, hcav), x_size=wjunc, y_size=ltaper)
  left_pad = rectangle(corner=(xcav_a/2 - wpad/2 + wjunc/2, ycav_a, hcav), x_size=wpad, y_size=ytunnel/2 - ltaper-ljunc/2)
  right_pad = rectangle(corner=(xcav_a/2 - wpad/2 + wjunc/2, ycav_a+ytunnel/2+ljunc/2+ltaper, hcav), x_size=wpad, y_size=ytunnel/2 - ltaper-ljunc/2)
boundaries and excitations:
  gnd_plane: Perfect E Objects=chip_ObjectFromFace1
  pads: Perfect E Objects=[left_pad, left_taper, right_pad, right_taper]
  LumpRLC1: Lumped RLC Objects=jj CurrentLine{(24.025, 18.975, 0.5) -> (24.025, 19.025, 0.5)} RLC_Type=Parallel Inductance=LJ
  cavity: Perfect E Faces=cav_a.face(+x, at (48, 29, 0.25), at (37, 20, 0.25), at (37, 18, 0.25), at (26, 19, 0.25), at (11, 18, 0.25), at (22, 19, 0.25), -z, at (11, 20, 0.25), at (0, 29, 0.25), -x, at (24, 38, 0.25)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)
setups:
  Setup1: HfssEigen MinimumFrequency=8.8GHz NumModes=4 MaxDeltaFreq=0.008 ConvergeOnRealFreq=true MaximumPasses=30 MinimumPasses=4 MinimumConvergedPasses=3 PercentRefinement=30 BasisOrder=2
source amplitudes:
  #-10:1: 1 0deg
  #-10:2: 0 0deg
  #-10:3, #-10:4: 0V_per_meter 0deg
optimetrics:
  LJ_sweep: Parametric Sim._Setups=[Setup1]
    sweep LJ: DEC 0.0001nH 10nH 3
  LJ_sweep_zoom: Parametric Sim._Setups=[Setup1]
    sweep LJ: LIN 0.2nH 1nH 0.2nH
field calculator expressions:
  Ex = Vector_E | ScalarX
  Ey = Vector_E | ScalarY
  Ez = Vector_E | ScalarZ
field plots:
  Vector_E1: E Field on Setup1 : LastAdaptive at Phase=0deg
  Vector_Jsurf1: Jsurf over cav_a.face(+z) on Setup1 : LastAdaptive at Phase=90deg
  Vector_H1: H Field on Setup1 : LastAdaptive at Phase=90deg
  Vector_E2: E Field in cav_a on Setup1 : LastAdaptive at Phase=0deg
reports:
  Solution Convergence Plot 1: MaxDeltaFreq vs Pass on Setup1 : AdaptivePass [LJ=all]; markers m1 at 10
  Eigen Modes Plot 1: re(Mode(1)), re(Mode(2)), re(Mode(3)), re(Mode(4)) vs LJ on Setup1 : LastAdaptive

design two_coupled_cavities_plus_jj_no_silicon_version_a_merged_gnd_sidewall_vacuum_full_geom_sweeps_bbq_latest (HFSS, HFSS Modal Network, model units mm)
variables:
  xsub = 90mm
  ysub = 90mm
  hsub = 5mm
  hcav = 0.5mm
  ycav = 22mm
  xcav = 24mm
  angle_a = 54.7
  angle_b = 35.3
  leg_length = 0.70617532mm
  h_chip = 0.4mm
  xchip = 24mm
  ychip = 46mm
  hchip = 0.45mm
  cavity_offset = 1mm
  xtunnel = 3mm
  ytunnel = 2mm
  lpad = 0.875mm
  wpad = 0.4mm
  ljunc = 50um
  wjunc = 50um
  ltaper = 100um
  LJ = 1nH
  chip_offset = 4mm
  xcav_a = 24mm
  ycav_a = 22mm
  xcav_b = 24mm
  ycav_b = 22mm
geometry:
  cav_a [vacuum] = box(corner=(0mm, 0mm, 0mm), size=(xcav_a, ycav_a, hcav))
  cav_b = box(corner=(0mm, ycav_a + cavity_offset, 0mm), size=(xcav_a, ycav_a, hcav))
  tunnel_coupler = box(corner=(xcav_a/2-xtunnel/2, ycav_a, 0mm), size=(xtunnel, ytunnel, hcav))
  chip [sapphire] = box(corner=(0, 0mm, hcav), size=(xchip, ychip, hchip))
  chip_vacuum [vacuum] = box(corner=(0, -chip_offset/2, hcav), size=(xchip, ychip + chip_offset, 2 * hchip))
  tunnel_coupler_ObjectFromFace1 = object_from(cav_a.face(1 of 6))
  chip_ObjectFromFace1 [sapphire] = object_from(chip.face(-z))
  chip_ObjectFromFace1.subtract(tunnel_coupler_ObjectFromFace1)
  cav_a.unite(cav_b, tunnel_coupler)
  left_taper = rectangle(corner=(xcav_a/2, ycav_a+ytunnel/2-ljunc/2-ltaper, hcav), x_size=wjunc, y_size=ltaper)
  right_taper = rectangle(corner=(xcav_a/2, ycav_a+ytunnel/2+ljunc/2, hcav), x_size=wjunc, y_size=ltaper)
  left_pad = rectangle(corner=(xcav_a/2 - wpad/2 + wjunc/2, ycav_a, hcav), x_size=wpad, y_size=ytunnel/2 - ltaper-ljunc/2)
  right_pad = rectangle(corner=(xcav_a/2 - wpad/2 + wjunc/2, ycav_a+ytunnel/2+ljunc/2+ltaper, hcav), x_size=wpad, y_size=ytunnel/2 - ltaper-ljunc/2)
  LP1 = polyline(z=0.5mm, xy in mm: (12.05, 22.975) (12, 22.975) (12, 23.025) (12.05, 23.025), closed, covered)
boundaries and excitations:
  gnd_plane: Perfect E Objects=chip_ObjectFromFace1
  pads: Perfect E Objects=[left_pad, left_taper, right_pad, right_taper]
  cavity: Perfect E Faces=cav_a.face(+x, at (24, 34, 0.25), at (13.5, 22.5, 0.25), at (10.5, 22.5, 0.25), -z, at (0, 34, 0.25), -x, at (12, 45, 0.25), -y)
  1: Lumped Port Faces=LP1.face LumpedPortType=Default Modes{Mode1{IntLine{(12.025, 23.025, 0.5) -> (12.025, 22.975, 0.5)} CharImp=Zpi RenormImp=50ohm}} Impedance=50ohm
setups:
  Setup1: HfssDriven MultipleAdaptiveFreqsSetup{Low=9.12GHz High=9.13GHz} MaxDeltaS=0.02 MaximumPasses=6 MinimumPasses=1 MinimumConvergedPasses=1 PercentRefinement=30 BasisOrder=1 PortAccuracy=2 DrivenSolverType="Direct Solver"
    sweep Sweep: 9.12GHz to 9.32GHz, 4001 points; 9.32GHz to 9.4GHz, 13 points; 9.4GHz to 9.5GHz, 501 points; 9.5GHz to 9.9GHz, 13 points; 9.9GHz to 10GHz, 501 points; 10GHz to 10.1GHz, 15 points; Type=Discrete
source amplitudes:
  1:1: 1W 0deg
optimetrics:
  LJ_sweep: Parametric
    sweep LJ: DEC 0.005nH 500nH 3
  LJ_xtunnel_sweep: Parametric
    sweep LJ: LIN 1nH 10nH 1nH
    sweep xtunnel: LIN 2mm 6mm 1mm
  cavity_offset_sweep: Parametric
    sweep cavity_offset: LIN 1mm 10mm 1mm
  LJ_sweep_fine: Parametric
    sweep LJ: LIN 7.5nH 12.5nH 0.5nH
reports:
  Y Parameter Plot 2: re(Y(1,1)), im(Y(1,1)) vs Freq on Setup1 : Sweep [cavity_offset=all xtunnel=all LJ=all]
